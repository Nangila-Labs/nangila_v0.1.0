* Nangila SPICE Auto-Synthesized Netlist
.SUBCKT INV_X1 A Z
M1 Z A 0 0 NMOS W=0.2u L=0.05u
M2 Z A 1 1 PMOS W=0.4u L=0.05u
.ENDS

.SUBCKT NAND2_X1 A1 A2 Z
M1 Z A1 1 1 PMOS W=0.4u L=0.05u
M2 Z A2 1 1 PMOS W=0.4u L=0.05u
M3 Z A1 int 0 NMOS W=0.2u L=0.05u
M4 int A2 0 0 NMOS W=0.2u L=0.05u
.ENDS

.SUBCKT AND2_X1 A1 A2 Z
X1 A1 A2 Z_bar NAND2_X1
X2 Z_bar Z INV_X1
.ENDS

.SUBCKT NOR2_X1 A1 A2 Z
M1 int1 A1 1 1 PMOS W=0.4u L=0.05u
M2 Z A2 int1 1 PMOS W=0.4u L=0.05u
M3 Z A1 0 0 NMOS W=0.2u L=0.05u
M4 Z A2 0 0 NMOS W=0.2u L=0.05u
.ENDS

.SUBCKT OR2_X1 A1 A2 Z
X1 A1 A2 Z_bar NOR2_X1
X2 Z_bar Z INV_X1
.ENDS

.SUBCKT XOR2_X1 A1 A2 Z
X1 A1 A2 int1 AND2_X1
X2 A1 A2 int2 NOR2_X1
X3 int1 int2 int3 NOR2_X1
X4 int3 Z INV_X1
.ENDS

.SUBCKT XNOR2_X1 A B Z
X1 A B Z_int XOR2_X1
X2 Z_int Z INV_X1
.ENDS

.SUBCKT BUF_X1 A Z
X1 A Z_bar INV_X1
X2 Z_bar Z INV_X1
.ENDS

.SUBCKT OAI21_X1 A B C Z
X1 A B C Z_bar AOI21_X1
X2 Z_bar Z INV_X1
.ENDS

.SUBCKT AOI21_X1 A B C Z
M1 Z A int1 1 PMOS W=0.4u L=0.05u
M2 int1 B 1 1 PMOS W=0.4u L=0.05u
M3 Z C 1 1 PMOS W=0.4u L=0.05u
M4 Z A 0 0 NMOS W=0.2u L=0.05u
M5 Z B 0 0 NMOS W=0.2u L=0.05u
M6 Z C 0 0 NMOS W=0.2u L=0.05u
.ENDS

.SUBCKT NAND3_X1 A1 A2 A3 Z
X1 A1 A2 int1 AND2_X1
X2 int1 A3 Z NAND2_X1
.ENDS

.SUBCKT AND3_X1 A1 A2 A3 Z
X1 A1 A2 A3 Z_bar NAND3_X1
X2 Z_bar Z INV_X1
.ENDS

.SUBCKT NOR3_X1 A1 A2 A3 Z
X1 A1 A2 int1 OR2_X1
X2 int1 A3 Z NOR2_X1
.ENDS

.SUBCKT OR3_X1 A1 A2 A3 Z
X1 A1 A2 A3 Z_bar NOR3_X1
X2 Z_bar Z INV_X1
.ENDS

.SUBCKT NAND4_X1 A1 A2 A3 A4 Z
X1 A1 A2 A3 int1 AND3_X1
X2 int1 A4 Z NAND2_X1
.ENDS

.SUBCKT AND4_X1 A1 A2 A3 A4 Z
X1 A1 A2 A3 A4 Z_bar NAND4_X1
X2 Z_bar Z INV_X1
.ENDS

.SUBCKT NOR4_X1 A1 A2 A3 A4 Z
X1 A1 A2 A3 int1 OR3_X1
X2 int1 A4 Z NOR2_X1
.ENDS

.SUBCKT OR4_X1 A1 A2 A3 A4 Z
X1 A1 A2 A3 A4 Z_bar NOR4_X1
X2 Z_bar Z INV_X1
.ENDS

.SUBCKT AOI22_X1 A B C D Z
X1 A B int1 AND2_X1
X2 C D int2 AND2_X1
X3 int1 int2 Z NOR2_X1
.ENDS

.SUBCKT OAI22_X1 A B C D Z
X1 A B int1 OR2_X1
X2 C D int2 OR2_X1
X3 int1 int2 Z NAND2_X1
.ENDS

.SUBCKT AOI211_X1 A B C D Z
X1 A B int1 AND2_X1
X2 int1 C D Z NOR3_X1
.ENDS

.SUBCKT OAI211_X1 A B C D Z
X1 A B int1 OR2_X1
X2 int1 C D Z NAND3_X1
.ENDS

.SUBCKT OAI33_X1 A B C D E F Z
X1 A B C int1 OR3_X1
X2 D E F int2 OR3_X1
X3 int1 int2 Z NAND2_X1
.ENDS

.SUBCKT AOI33_X1 A B C D E F Z
X1 A B C int1 AND3_X1
X2 D E F int2 AND3_X1
X3 int1 int2 Z NOR2_X1
.ENDS

.SUBCKT MUX2_X1 A B S Z
X1 S S_bar INV_X1
X2 A S_bar int1 AND2_X1
X3 B S int2 AND2_X1
X4 int1 int2 Z OR2_X1
.ENDS

.SUBCKT DFF_X1 D C Q QN
X1 D Q_int INV_X1
X2 Q_int Q INV_X1
X3 Q_int QN INV_X1
.ENDS

.SUBCKT DFFR_X1 D C RN Q QN
X1 D Q_int INV_X1
X2 Q_int Q INV_X1
X3 Q_int QN INV_X1
.ENDS

.SUBCKT DFFS_X1 C D Q QN SN
X1 D Q_int INV_X1
X2 Q_int Q INV_X1
X3 Q_int QN INV_X1
.ENDS

.SUBCKT DFFRS_X1 C D Q QN RN SN
X1 D Q_int INV_X1
X2 Q_int Q INV_X1
X3 Q_int QN INV_X1
.ENDS

* Provide VDD power source explicitly
Vvdd 1 0 1.8

* Auto-extracted Inputs:
V_G1 G1 0 1.8
V_G2 G2 0 0.0
V_G3 G3 0 1.8
V_G4 G4 0 0.0
V_G5 G5 0 1.8
V_G6 G6 0 0.0
V_G7 G7 0 1.8
V_G8 G8 0 0.0
V_G9 G9 0 1.8
V_G10 G10 0 0.0
V_G11 G11 0 1.8
V_G12 G12 0 0.0
V_G13 G13 0 1.8
V_G14 G14 0 0.0
V_G15 G15 0 1.8
V_G16 G16 0 0.0
V_G17 G17 0 1.8
V_G18 G18 0 0.0
V_G19 G19 0 1.8
V_G20 G20 0 0.0
V_G21 G21 0 1.8
V_G22 G22 0 0.0
V_G23 G23 0 1.8
V_G24 G24 0 0.0
V_G25 G25 0 1.8
V_G26 G26 0 0.0
V_G27 G27 0 1.8
V_G28 G28 0 0.0
V_G29 G29 0 1.8
V_G30 G30 0 0.0
V_G31 G31 0 1.8
V_G32 G32 0 0.0
V_G33 G33 0 1.8
V_G34 G34 0 0.0
V_G35 G35 0 1.8
V_G36 G36 0 0.0
V_G37 G37 0 1.8
V_G38 G38 0 0.0
V_G39 G39 0 1.8
V_G40 G40 0 0.0
V_G41 G41 0 1.8

* Yosys Generated Netlist:
* SPICE netlist generated by Yosys 0.62 (git sha1 7326bb7d6641500ecb285c291a54a662cb1e76cf, clang++ 17.0.0 -fPIC -O3)

X0 G33 G41 1 NAND2_X1
X1 G19 G20 2 XNOR2_X1
X2 G17 G18 3 XNOR2_X1
X3 2 3 4 XNOR2_X1
X4 1 4 5 XNOR2_X1
X5 G23 G24 6 XNOR2_X1
X6 G21 G22 7 XNOR2_X1
X7 6 7 8 XNOR2_X1
X8 G9 G13 9 XOR2_X1
X9 G1 G5 10 XNOR2_X1
X10 9 10 11 XNOR2_X1
X11 8 11 12 XNOR2_X1
X12 5 12 13 XOR2_X1
X13 5 12 14 XNOR2_X1
X14 G3 G4 15 XOR2_X1
X15 G1 G2 16 XNOR2_X1
X16 15 16 17 XNOR2_X1
X17 G41 G37 18 NAND2_X1
X18 17 18 19 XNOR2_X1
X19 G7 G8 20 XNOR2_X1
X20 G5 G6 21 XNOR2_X1
X21 20 21 22 XNOR2_X1
X22 G17 G21 23 XNOR2_X1
X23 G25 G29 24 XOR2_X1
X24 23 24 25 XNOR2_X1
X25 22 25 26 XNOR2_X1
X26 19 26 27 XNOR2_X1
X27 27 28 INV_X1
X28 G11 G12 29 XNOR2_X1
X29 G9 G10 30 XNOR2_X1
X30 29 30 31 XNOR2_X1
X31 G41 G38 32 NAND2_X1
X32 31 32 33 XOR2_X1
X33 G15 G16 34 XNOR2_X1
X34 G13 G14 35 XNOR2_X1
X35 34 35 36 XNOR2_X1
X36 G18 G22 37 XNOR2_X1
X37 G26 G30 38 XOR2_X1
X38 37 38 39 XNOR2_X1
X39 36 39 40 XNOR2_X1
X40 33 40 41 XNOR2_X1
X41 28 41 42 NAND2_X1
X42 G41 G39 43 NAND2_X1
X43 17 43 44 XNOR2_X1
X44 G19 G23 45 XNOR2_X1
X45 G27 G31 46 XOR2_X1
X46 45 46 47 XNOR2_X1
X47 31 47 48 XNOR2_X1
X48 44 48 49 XNOR2_X1
X49 49 50 INV_X1
X50 G41 G40 51 NAND2_X1
X51 22 51 52 XOR2_X1
X52 G20 G24 53 XNOR2_X1
X53 G28 G32 54 XOR2_X1
X54 53 54 55 XNOR2_X1
X55 36 55 56 XNOR2_X1
X56 52 56 57 XNOR2_X1
X57 50 57 58 NAND2_X1
X58 G41 G34 59 NAND2_X1
X59 G31 G32 60 XNOR2_X1
X60 G29 G30 61 XNOR2_X1
X61 60 61 62 XNOR2_X1
X62 59 62 63 XNOR2_X1
X63 G27 G28 64 XNOR2_X1
X64 G25 G26 65 XNOR2_X1
X65 64 65 66 XNOR2_X1
X66 G10 G14 67 XOR2_X1
X67 G2 G6 68 XNOR2_X1
X68 67 68 69 XNOR2_X1
X69 66 69 70 XNOR2_X1
X70 63 70 71 XOR2_X1
X71 63 70 72 XNOR2_X1
X72 G41 G35 73 NAND2_X1
X73 4 73 74 XNOR2_X1
X74 G3 G7 75 XNOR2_X1
X75 G11 G15 76 XOR2_X1
X76 75 76 77 XNOR2_X1
X77 66 77 78 XNOR2_X1
X78 74 78 79 XNOR2_X1
X79 14 71 79 80 NOR3_X1
X80 13 72 79 81 NOR3_X1
X81 G41 G36 82 NAND2_X1
X82 8 82 83 XNOR2_X1
X83 G4 G8 84 XNOR2_X1
X84 G12 G16 85 XOR2_X1
X85 84 85 86 XNOR2_X1
X86 62 86 87 XNOR2_X1
X87 83 87 88 XNOR2_X1
X88 88 89 INV_X1
X89 89 81 80 90 OAI21_X1
X90 79 89 91 AND2_X1
X91 79 88 92 XOR2_X1
X92 13 71 92 93 NAND3_X1
X93 42 58 90 93 94 AOI211_X1
X94 14 94 95 NAND2_X1
X95 G1 95 G1324 XOR2_X1
X96 72 94 96 NAND2_X1
X97 G2 96 G1325 XOR2_X1
X98 79 94 97 NAND2_X1
X99 G3 97 G1326 XOR2_X1
X100 88 94 98 NAND2_X1
X101 G4 98 G1327 XOR2_X1
X102 50 57 99 OR2_X1
X103 42 99 93 90 100 AOI211_X1
X104 14 100 101 NAND2_X1
X105 G5 101 G1328 XOR2_X1
X106 72 100 102 NAND2_X1
X107 G6 102 G1329 XOR2_X1
X108 79 100 103 NAND2_X1
X109 G7 103 G1330 XOR2_X1
X110 88 100 104 NAND2_X1
X111 G8 104 G1331 XOR2_X1
X112 28 41 105 OR2_X1
X113 58 105 93 90 106 AOI211_X1
X114 14 106 107 NAND2_X1
X115 G9 107 G1332 XOR2_X1
X116 72 106 108 NAND2_X1
X117 G10 108 G1333 XOR2_X1
X118 79 106 109 NAND2_X1
X119 G11 109 G1334 XOR2_X1
X120 88 106 110 NAND2_X1
X121 G12 110 G1335 XOR2_X1
X122 99 105 90 93 111 AOI211_X1
X123 14 111 112 NAND2_X1
X124 G13 112 G1336 XOR2_X1
X125 72 111 113 NAND2_X1
X126 G14 113 G1337 XOR2_X1
X127 79 111 114 NAND2_X1
X128 G15 114 G1338 XOR2_X1
X129 88 111 115 NAND2_X1
X130 G16 115 G1339 XOR2_X1
X131 27 41 116 XNOR2_X1
X132 49 57 117 NAND2_X1
X133 49 57 118 XNOR2_X1
X134 27 41 119 NAND2_X1
X135 116 117 118 119 120 OAI22_X1
X136 14 71 91 120 121 NAND4_X1
X137 27 121 122 NOR2_X1
X138 G17 122 G1340 XNOR2_X1
X139 41 121 123 NOR2_X1
X140 G18 123 G1341 XNOR2_X1
X141 49 121 124 NOR2_X1
X142 G19 124 G1342 XNOR2_X1
X143 57 121 125 NOR2_X1
X144 G20 125 G1343 XNOR2_X1
X145 81 88 120 126 NAND3_X1
X146 27 126 127 NOR2_X1
X147 G21 127 G1344 XNOR2_X1
X148 41 126 128 NOR2_X1
X149 G22 128 G1345 XNOR2_X1
X150 49 126 129 NOR2_X1
X151 G23 129 G1346 XNOR2_X1
X152 57 126 130 NOR2_X1
X153 G24 130 G1347 XNOR2_X1
X154 13 72 91 120 131 NAND4_X1
X155 27 131 132 NOR2_X1
X156 G25 132 G1348 XNOR2_X1
X157 41 131 133 NOR2_X1
X158 G26 133 G1349 XNOR2_X1
X159 49 131 134 NOR2_X1
X160 G27 134 G1350 XNOR2_X1
X161 57 131 135 NOR2_X1
X162 G28 135 G1351 XNOR2_X1
X163 80 88 120 136 NAND3_X1
X164 27 136 137 NOR2_X1
X165 G29 137 G1352 XNOR2_X1
X166 41 136 138 NOR2_X1
X167 G30 138 G1353 XNOR2_X1
X168 49 136 139 NOR2_X1
X169 G31 139 G1354 XNOR2_X1
X170 57 136 140 NOR2_X1
X171 G32 140 G1355 XNOR2_X1

************************
* end of SPICE netlist *
************************

* Anti-Floating Pull-Downs (GMIN)
R_PD_0 96 0 100meg
R_PD_1 101 0 100meg
R_PD_2 G31 0 100meg
R_PD_3 117 0 100meg
R_PD_4 38 0 100meg
R_PD_5 21 0 100meg
R_PD_6 69 0 100meg
R_PD_7 50 0 100meg
R_PD_8 G32 0 100meg
R_PD_9 109 0 100meg
R_PD_10 110 0 100meg
R_PD_11 119 0 100meg
R_PD_12 60 0 100meg
R_PD_13 65 0 100meg
R_PD_14 72 0 100meg
R_PD_15 24 0 100meg
R_PD_16 G25 0 100meg
R_PD_17 55 0 100meg
R_PD_18 57 0 100meg
R_PD_19 87 0 100meg
R_PD_20 9 0 100meg
R_PD_21 G30 0 100meg
R_PD_22 39 0 100meg
R_PD_23 12 0 100meg
R_PD_24 G20 0 100meg
R_PD_25 18 0 100meg
R_PD_26 G7 0 100meg
R_PD_27 G15 0 100meg
R_PD_28 76 0 100meg
R_PD_29 G1330 0 100meg
R_PD_30 126 0 100meg
R_PD_31 136 0 100meg
R_PD_32 140 0 100meg
R_PD_33 G3 0 100meg
R_PD_34 137 0 100meg
R_PD_35 23 0 100meg
R_PD_36 30 0 100meg
R_PD_37 103 0 100meg
R_PD_38 66 0 100meg
R_PD_39 40 0 100meg
R_PD_40 G17 0 100meg
R_PD_41 51 0 100meg
R_PD_42 132 0 100meg
R_PD_43 29 0 100meg
R_PD_44 52 0 100meg
R_PD_45 102 0 100meg
R_PD_46 90 0 100meg
R_PD_47 G1331 0 100meg
R_PD_48 43 0 100meg
R_PD_49 26 0 100meg
R_PD_50 G8 0 100meg
R_PD_51 83 0 100meg
R_PD_52 6 0 100meg
R_PD_53 127 0 100meg
R_PD_54 135 0 100meg
R_PD_55 G11 0 100meg
R_PD_56 107 0 100meg
R_PD_57 G1353 0 100meg
R_PD_58 64 0 100meg
R_PD_59 1 0 100meg
R_PD_60 100 0 100meg
R_PD_61 G28 0 100meg
R_PD_62 G1345 0 100meg
R_PD_63 61 0 100meg
R_PD_64 2 0 100meg
R_PD_65 G1351 0 100meg
R_PD_66 G1343 0 100meg
R_PD_67 116 0 100meg
R_PD_68 73 0 100meg
R_PD_69 G1348 0 100meg
R_PD_70 48 0 100meg
R_PD_71 G1325 0 100meg
R_PD_72 75 0 100meg
R_PD_73 106 0 100meg
R_PD_74 58 0 100meg
R_PD_75 G4 0 100meg
R_PD_76 G1324 0 100meg
R_PD_77 131 0 100meg
R_PD_78 10 0 100meg
R_PD_79 G36 0 100meg
R_PD_80 G1347 0 100meg
R_PD_81 115 0 100meg
R_PD_82 89 0 100meg
R_PD_83 G33 0 100meg
R_PD_84 82 0 100meg
R_PD_85 105 0 100meg
R_PD_86 121 0 100meg
R_PD_87 56 0 100meg
R_PD_88 97 0 100meg
R_PD_89 68 0 100meg
R_PD_90 74 0 100meg
R_PD_91 15 0 100meg
R_PD_92 46 0 100meg
R_PD_93 85 0 100meg
R_PD_94 37 0 100meg
R_PD_95 4 0 100meg
R_PD_96 G1329 0 100meg
R_PD_97 134 0 100meg
R_PD_98 G1355 0 100meg
R_PD_99 3 0 100meg
R_PD_100 79 0 100meg
R_PD_101 20 0 100meg
R_PD_102 G19 0 100meg
R_PD_103 G1352 0 100meg
R_PD_104 124 0 100meg
R_PD_105 7 0 100meg
R_PD_106 8 0 100meg
R_PD_107 16 0 100meg
R_PD_108 G9 0 100meg
R_PD_109 G40 0 100meg
R_PD_110 70 0 100meg
R_PD_111 99 0 100meg
R_PD_112 G13 0 100meg
R_PD_113 77 0 100meg
R_PD_114 G18 0 100meg
R_PD_115 G41 0 100meg
R_PD_116 54 0 100meg
R_PD_117 108 0 100meg
R_PD_118 35 0 100meg
R_PD_119 112 0 100meg
R_PD_120 G6 0 100meg
R_PD_121 86 0 100meg
R_PD_122 G2 0 100meg
R_PD_123 G21 0 100meg
R_PD_124 17 0 100meg
R_PD_125 G14 0 100meg
R_PD_126 114 0 100meg
R_PD_127 28 0 100meg
R_PD_128 G1 0 100meg
R_PD_129 120 0 100meg
R_PD_130 34 0 100meg
R_PD_131 36 0 100meg
R_PD_132 G1344 0 100meg
R_PD_133 G1335 0 100meg
R_PD_134 118 0 100meg
R_PD_135 G34 0 100meg
R_PD_136 138 0 100meg
R_PD_137 33 0 100meg
R_PD_138 G38 0 100meg
R_PD_139 98 0 100meg
R_PD_140 G1334 0 100meg
R_PD_141 G10 0 100meg
R_PD_142 G1336 0 100meg
R_PD_143 53 0 100meg
R_PD_144 59 0 100meg
R_PD_145 94 0 100meg
R_PD_146 113 0 100meg
R_PD_147 G1326 0 100meg
R_PD_148 47 0 100meg
R_PD_149 128 0 100meg
R_PD_150 63 0 100meg
R_PD_151 81 0 100meg
R_PD_152 42 0 100meg
R_PD_153 88 0 100meg
R_PD_154 125 0 100meg
R_PD_155 93 0 100meg
R_PD_156 G12 0 100meg
R_PD_157 G1327 0 100meg
R_PD_158 G1341 0 100meg
R_PD_159 92 0 100meg
R_PD_160 123 0 100meg
R_PD_161 G23 0 100meg
R_PD_162 22 0 100meg
R_PD_163 G1350 0 100meg
R_PD_164 G1337 0 100meg
R_PD_165 G37 0 100meg
R_PD_166 G29 0 100meg
R_PD_167 25 0 100meg
R_PD_168 139 0 100meg
R_PD_169 80 0 100meg
R_PD_170 G1340 0 100meg
R_PD_171 44 0 100meg
R_PD_172 45 0 100meg
R_PD_173 71 0 100meg
R_PD_174 G1349 0 100meg
R_PD_175 G1338 0 100meg
R_PD_176 32 0 100meg
R_PD_177 41 0 100meg
R_PD_178 G26 0 100meg
R_PD_179 130 0 100meg
R_PD_180 14 0 100meg
R_PD_181 104 0 100meg
R_PD_182 49 0 100meg
R_PD_183 62 0 100meg
R_PD_184 19 0 100meg
R_PD_185 122 0 100meg
R_PD_186 G5 0 100meg
R_PD_187 84 0 100meg
R_PD_188 111 0 100meg
R_PD_189 G16 0 100meg
R_PD_190 31 0 100meg
R_PD_191 G35 0 100meg
R_PD_192 G1339 0 100meg
R_PD_193 129 0 100meg
R_PD_194 95 0 100meg
R_PD_195 G1332 0 100meg
R_PD_196 27 0 100meg
R_PD_197 G1354 0 100meg
R_PD_198 67 0 100meg
R_PD_199 78 0 100meg
R_PD_200 G27 0 100meg
R_PD_201 G22 0 100meg
R_PD_202 G24 0 100meg
R_PD_203 G1333 0 100meg
R_PD_204 91 0 100meg
R_PD_205 13 0 100meg
R_PD_206 G1346 0 100meg
R_PD_207 G1342 0 100meg
R_PD_208 11 0 100meg
R_PD_209 133 0 100meg
R_PD_210 G39 0 100meg
R_PD_211 G1328 0 100meg
R_PD_212 5 0 100meg

* Transient Simulation Directive
.TRAN 100p 10n
