* Nangila SPICE Auto-Synthesized Netlist
.SUBCKT INV_X1 A Z
M1 Z A 0 0 NMOS W=0.2u L=0.05u
M2 Z A 1 1 PMOS W=0.4u L=0.05u
.ENDS

.SUBCKT NAND2_X1 A1 A2 Z
M1 Z A1 1 1 PMOS W=0.4u L=0.05u
M2 Z A2 1 1 PMOS W=0.4u L=0.05u
M3 Z A1 int 0 NMOS W=0.2u L=0.05u
M4 int A2 0 0 NMOS W=0.2u L=0.05u
.ENDS

.SUBCKT AND2_X1 A1 A2 Z
X1 A1 A2 Z_bar NAND2_X1
X2 Z_bar Z INV_X1
.ENDS

.SUBCKT NOR2_X1 A1 A2 Z
M1 int1 A1 1 1 PMOS W=0.4u L=0.05u
M2 Z A2 int1 1 PMOS W=0.4u L=0.05u
M3 Z A1 0 0 NMOS W=0.2u L=0.05u
M4 Z A2 0 0 NMOS W=0.2u L=0.05u
.ENDS

.SUBCKT OR2_X1 A1 A2 Z
X1 A1 A2 Z_bar NOR2_X1
X2 Z_bar Z INV_X1
.ENDS

.SUBCKT XOR2_X1 A1 A2 Z
X1 A1 A2 int1 AND2_X1
X2 A1 A2 int2 NOR2_X1
X3 int1 int2 int3 NOR2_X1
X4 int3 Z INV_X1
.ENDS

.SUBCKT XNOR2_X1 A B Z
X1 A B Z_int XOR2_X1
X2 Z_int Z INV_X1
.ENDS

.SUBCKT BUF_X1 A Z
X1 A Z_bar INV_X1
X2 Z_bar Z INV_X1
.ENDS

.SUBCKT OAI21_X1 A B C Z
X1 A B C Z_bar AOI21_X1
X2 Z_bar Z INV_X1
.ENDS

.SUBCKT AOI21_X1 A B C Z
M1 Z A int1 1 PMOS W=0.4u L=0.05u
M2 int1 B 1 1 PMOS W=0.4u L=0.05u
M3 Z C 1 1 PMOS W=0.4u L=0.05u
M4 Z A 0 0 NMOS W=0.2u L=0.05u
M5 Z B 0 0 NMOS W=0.2u L=0.05u
M6 Z C 0 0 NMOS W=0.2u L=0.05u
.ENDS

.SUBCKT NAND3_X1 A1 A2 A3 Z
X1 A1 A2 int1 AND2_X1
X2 int1 A3 Z NAND2_X1
.ENDS

.SUBCKT AND3_X1 A1 A2 A3 Z
X1 A1 A2 A3 Z_bar NAND3_X1
X2 Z_bar Z INV_X1
.ENDS

.SUBCKT NOR3_X1 A1 A2 A3 Z
X1 A1 A2 int1 OR2_X1
X2 int1 A3 Z NOR2_X1
.ENDS

.SUBCKT OR3_X1 A1 A2 A3 Z
X1 A1 A2 A3 Z_bar NOR3_X1
X2 Z_bar Z INV_X1
.ENDS

.SUBCKT NAND4_X1 A1 A2 A3 A4 Z
X1 A1 A2 A3 int1 AND3_X1
X2 int1 A4 Z NAND2_X1
.ENDS

.SUBCKT AND4_X1 A1 A2 A3 A4 Z
X1 A1 A2 A3 A4 Z_bar NAND4_X1
X2 Z_bar Z INV_X1
.ENDS

.SUBCKT NOR4_X1 A1 A2 A3 A4 Z
X1 A1 A2 A3 int1 OR3_X1
X2 int1 A4 Z NOR2_X1
.ENDS

.SUBCKT OR4_X1 A1 A2 A3 A4 Z
X1 A1 A2 A3 A4 Z_bar NOR4_X1
X2 Z_bar Z INV_X1
.ENDS

.SUBCKT AOI22_X1 A B C D Z
X1 A B int1 AND2_X1
X2 C D int2 AND2_X1
X3 int1 int2 Z NOR2_X1
.ENDS

.SUBCKT OAI22_X1 A B C D Z
X1 A B int1 OR2_X1
X2 C D int2 OR2_X1
X3 int1 int2 Z NAND2_X1
.ENDS

.SUBCKT AOI211_X1 A B C D Z
X1 A B int1 AND2_X1
X2 int1 C D Z NOR3_X1
.ENDS

.SUBCKT OAI211_X1 A B C D Z
X1 A B int1 OR2_X1
X2 int1 C D Z NAND3_X1
.ENDS

.SUBCKT OAI33_X1 A B C D E F Z
X1 A B C int1 OR3_X1
X2 D E F int2 OR3_X1
X3 int1 int2 Z NAND2_X1
.ENDS

.SUBCKT AOI33_X1 A B C D E F Z
X1 A B C int1 AND3_X1
X2 D E F int2 AND3_X1
X3 int1 int2 Z NOR2_X1
.ENDS

.SUBCKT MUX2_X1 A B S Z
X1 S S_bar INV_X1
X2 A S_bar int1 AND2_X1
X3 B S int2 AND2_X1
X4 int1 int2 Z OR2_X1
.ENDS

.SUBCKT DFF_X1 D C Q QN
X1 D Q_int INV_X1
X2 Q_int Q INV_X1
X3 Q_int QN INV_X1
.ENDS

.SUBCKT DFFR_X1 D C RN Q QN
X1 D Q_int INV_X1
X2 Q_int Q INV_X1
X3 Q_int QN INV_X1
.ENDS

.SUBCKT DFFS_X1 C D Q QN SN
X1 D Q_int INV_X1
X2 Q_int Q INV_X1
X3 Q_int QN INV_X1
.ENDS

.SUBCKT DFFRS_X1 C D Q QN RN SN
X1 D Q_int INV_X1
X2 Q_int Q INV_X1
X3 Q_int QN INV_X1
.ENDS

* Provide VDD power source explicitly
Vvdd 1 0 1.8

* Auto-extracted Inputs:
V_CK CK 0 1.8
V_D D 0 0.0
V_CK CK 0 1.8
V_G0 G0 0 0.0
V_G1 G1 0 1.8
V_G2 G2 0 0.0
V_G3 G3 0 1.8
V_G4 G4 0 0.0
V_G5 G5 0 1.8
V_G6 G6 0 0.0
V_G7 G7 0 1.8
V_G8 G8 0 0.0
V_G9 G9 0 1.8
V_G10 G10 0 0.0
V_G11 G11 0 1.8
V_G12 G12 0 0.0
V_G13 G13 0 1.8

* Yosys Generated Netlist:
* SPICE netlist generated by Yosys 0.62 (git sha1 7326bb7d6641500ecb285c291a54a662cb1e76cf, clang++ 17.0.0 -fPIC -O3)

.SUBCKT dff CK Q D
X0 CK D Q 1 DFF_X1
.ENDS dff

X0 G8 1 INV_X1
X1 G0 2 INV_X1
X2 G11 3 INV_X1
X3 G4 4 INV_X1
X4 G2 5 INV_X1
X5 G3 6 INV_X1
X6 G9 7 INV_X1
X7 G6 8 INV_X1
X8 G31 9 INV_X1
X9 G5 10 INV_X1
X10 G1 11 INV_X1
X11 G7 12 INV_X1
X12 G10 13 INV_X1
X13 G12 14 INV_X1
X14 G32 15 INV_X1
X15 G34 16 INV_X1
X16 G13 17 INV_X1
X17 G41 G546 INV_X1
X18 G7 13 18 NAND2_X1
X19 G0 G4 18 G511 NOR3_X1
X20 5 6 19 NAND2_X1
X21 6 10 20 NOR2_X1
X22 G3 G5 21 NAND2_X1
X23 4 6 10 G1 22 OAI211_X1
X24 19 22 23 NAND2_X1
X25 G4 G5 24 NOR2_X1
X26 4 10 25 NAND2_X1
X27 G4 6 26 NOR2_X1
X28 2 23 24 26 27 OAI22_X1
X29 G6 G30 28 NOR2_X1
X30 G8 G10 29 NAND2_X1
X31 G8 G7 30 NOR2_X1
X32 30 31 INV_X1
X33 G30 G7 32 NAND2_X1
X34 G8 9 32 G6 33 OAI211_X1
X35 G9 29 31 33 34 AOI22_X1
X36 G11 28 34 35 OAI21_X1
X37 G11 G10 36 NOR2_X1
X38 G11 G7 37 NOR2_X1
X39 7 36 32 G6 38 OAI211_X1
X40 G9 37 G10 G8 39 OAI211_X1
X41 G8 G31 38 39 40 AOI22_X1
X42 40 41 INV_X1
X43 G46 27 35 41 42 AND4_X1
X44 14 G13 43 NOR2_X1
X45 42 43 44 AND2_X1
X46 42 43 45 NAND2_X1
X47 G1 26 46 NAND2_X1
X48 46 G1 10 4 20 47 OAI221_X1
X49 2 5 48 NOR2_X1
X50 G2 G1 49 NAND2_X1
X51 G0 24 26 49 50 NOR4_X1
X52 50 48 47 51 AOI21_X1
X53 G4 G6 52 NAND2_X1
X54 G11 G4 G6 G5 53 NAND4_X1
X55 53 54 INV_X1
X56 G10 30 55 NAND2_X1
X57 G9 G10 30 56 AND3_X1
X58 54 56 57 AND2_X1
X59 8 G36 58 NAND2_X1
X60 G9 18 59 NOR2_X1
X61 1 G9 12 G10 60 NOR4_X1
X62 G8 59 61 NAND2_X1
X63 56 60 62 NOR2_X1
X64 54 56 60 63 OAI21_X1
X65 19 58 63 64 AOI21_X1
X66 G11 G9 65 AND2_X1
X67 1 7 66 NOR2_X1
X68 G8 G11 G9 67 NAND3_X1
X69 12 13 68 NOR2_X1
X70 G7 G10 69 NAND2_X1
X71 69 65 G8 70 AOI21_X1
X72 G9 13 71 NAND2_X1
X73 G9 G7 72 NAND2_X1
X74 G10 72 73 NOR2_X1
X75 1 G7 74 NOR2_X1
X76 G8 G30 12 75 AND3_X1
X77 73 75 67 68 76 AOI211_X1
X78 15 76 77 OR2_X1
X79 G12 G13 78 NOR2_X1
X80 77 78 79 NAND2_X1
X81 64 77 78 80 NAND3_X1
X82 80 51 45 G530 OAI21_X1
X83 G2 G5 81 NAND2_X1
X84 G4 G2 82 NAND2_X1
X85 G2 6 83 NAND2_X1
X86 G11 G35 24 84 AND3_X1
X87 5 G3 84 85 AOI21_X1
X88 21 52 86 NOR2_X1
X89 21 52 87 OR2_X1
X90 67 69 88 NOR2_X1
X91 67 69 89 OR2_X1
X92 G8 G11 G7 G10 90 NOR4_X1
X93 G9 90 91 AND2_X1
X94 86 91 92 NAND2_X1
X95 86 88 91 93 OAI21_X1
X96 G3 G6 94 NAND2_X1
X97 G4 G3 95 NAND2_X1
X98 G4 G3 G6 96 NAND3_X1
X99 3 G5 96 97 NOR3_X1
X100 97 60 56 98 OAI21_X1
X101 1 7 G7 G10 99 NOR4_X1
X102 G2 97 99 100 AOI21_X1
X103 85 93 98 100 101 AOI22_X1
X104 17 77 101 64 102 OAI211_X1
X105 G1 96 103 OR2_X1
X106 G4 11 94 104 OR3_X1
X107 G8 103 104 105 NAND3_X1
X108 G4 G6 106 NOR2_X1
X109 G3 11 106 107 NAND3_X1
X110 G11 7 G7 13 108 NAND4_X1
X111 108 107 1 109 AOI21_X1
X112 1 65 110 NAND2_X1
X113 1 G10 65 111 NAND3_X1
X114 G10 67 112 OR2_X1
X115 111 112 103 113 OAI21_X1
X116 G7 103 104 114 AOI21_X1
X117 105 109 113 114 115 AOI22_X1
X118 88 91 116 NOR2_X1
X119 5 G5 115 116 49 87 117 OAI33_X1
X120 117 118 INV_X1
X121 G13 117 119 NAND2_X1
X122 102 119 11 120 OAI21_X1
X123 G11 G3 G6 24 121 NAND4_X1
X124 25 62 122 NOR2_X1
X125 92 121 62 123 OAI21_X1
X126 G2 123 124 AND2_X1
X127 G2 6 125 NOR2_X1
X128 5 G3 126 NAND2_X1
X129 G2 96 102 127 OR3_X1
X130 G2 11 128 NAND2_X1
X131 52 128 129 NOR2_X1
X132 52 119 128 130 NOR3_X1
X133 G13 117 129 131 NAND3_X1
X134 111 127 131 132 AOI21_X1
X135 83 126 4 20 133 OAI211_X1
X136 4 G5 134 NOR2_X1
X137 G4 10 135 NAND2_X1
X138 6 10 136 NAND2_X1
X139 6 134 137 NAND2_X1
X140 G6 G5 138 NOR2_X1
X141 128 134 138 139 NOR3_X1
X142 G4 G2 G1 140 NAND3_X1
X143 81 140 141 NAND2_X1
X144 4 G5 142 NAND2_X1
X145 20 52 106 G5 G6 133 143 AOI222_X1
X146 11 137 143 144 AOI21_X1
X147 G6 81 140 145 AOI21_X1
X148 70 73 75 139 144 145 146 OAI33_X1
X149 54 60 106 G36 147 AOI22_X1
X150 17 G43 146 147 19 102 148 OAI33_X1
X151 132 148 120 124 149 AOI211_X1
X152 G2 21 150 NOR2_X1
X153 83 128 151 NAND2_X1
X154 G4 150 151 152 OAI21_X1
X155 5 6 G5 G1 153 NAND4_X1
X156 46 137 152 153 154 NAND4_X1
X157 G0 44 154 155 NAND3_X1
X158 155 149 G12 G532 OAI21_X1
X159 60 99 156 OR2_X1
X160 120 122 130 156 157 AOI22_X1
X161 G12 94 158 OR2_X1
X162 G2 G12 102 159 NOR3_X1
X163 97 156 160 NAND2_X1
X164 160 G44 G3 161 OAI21_X1
X165 159 161 162 NAND2_X1
X166 2 87 89 163 NOR3_X1
X167 7 G6 164 NAND2_X1
X168 164 165 INV_X1
X169 G8 G37 166 NAND2_X1
X170 55 136 164 166 18 21 167 OAI33_X1
X171 2 G11 4 167 168 AND4_X1
X172 G2 G1 163 168 169 OAI211_X1
X173 14 G13 42 170 OR3_X1
X174 170 171 INV_X1
X175 169 170 172 OR2_X1
X176 1 172 173 OR2_X1
X177 G38 G37 174 NAND2_X1
X178 162 173 174 158 157 G535 OAI221_X1
X179 G9 68 175 NAND2_X1
X180 25 61 94 175 87 1 176 OAI33_X1
X181 G5 62 103 119 177 NOR4_X1
X182 177 176 120 178 AOI21_X1
X183 G6 89 135 179 NOR3_X1
X184 G6 25 180 NOR2_X1
X185 57 179 180 90 181 AOI211_X1
X186 98 181 G3 182 OAI21_X1
X187 159 182 183 NAND2_X1
X188 2 52 175 184 NOR3_X1
X189 184 165 G38 185 AOI21_X1
X190 183 185 173 178 G12 G537 OAI221_X1
X191 14 G13 146 186 NAND3_X1
X192 64 79 101 187 NOR3_X1
X193 187 171 169 188 AOI21_X1
X194 188 186 117 G539 OAI21_X1
X195 1 G7 189 NAND2_X1
X196 12 29 190 XNOR2_X1
X197 74 13 G9 191 OAI21_X1
X198 110 191 36 71 74 192 OAI221_X1
X199 8 192 193 NOR2_X1
X200 G6 68 G9 194 AOI21_X1
X201 7 16 190 193 194 45 G547 OAI33_X1
X202 G7 29 65 195 NAND3_X1
X203 G9 69 196 NOR2_X1
X204 G11 71 74 196 197 OAI211_X1
X205 195 197 198 AND2_X1
X206 G42 45 198 16 G548 OAI22_X1
X207 G4 G1 199 NAND2_X1
X208 199 G3 G0 200 AOI21_X1
X209 G12 17 146 201 NOR3_X1
X210 8 20 202 NOR2_X1
X211 G4 138 202 83 203 AOI211_X1
X212 G3 52 204 NOR2_X1
X213 G5 204 205 NAND2_X1
X214 G2 134 206 NAND2_X1
X215 205 206 G2 21 207 OAI211_X1
X216 G1 201 203 207 208 OAI211_X1
X217 6 G13 G33 209 OR3_X1
X218 G12 G13 77 210 NOR3_X1
X219 81 G3 G4 211 AOI21_X1
X220 44 200 210 211 212 AOI22_X1
X221 208 209 212 G549 NAND3_X1
X222 G0 199 213 OR2_X1
X223 G4 G5 G1 214 NAND3_X1
X224 141 201 214 215 NAND3_X1
X225 21 G2 G4 216 AOI21_X1
X226 2 G29 213 6 217 OAI22_X1
X227 210 216 217 44 218 AOI22_X1
X228 209 215 218 G550 NAND3_X1
X229 G1 48 219 NOR2_X1
X230 G3 219 48 4 220 AOI211_X1
X231 G0 G3 199 221 NAND3_X1
X232 213 221 222 NAND2_X1
X233 G5 44 220 222 223 OAI211_X1
X234 G4 G39 210 224 NAND3_X1
X235 G1 82 126 199 225 OAI22_X1
X236 G5 225 226 AND2_X1
X237 G2 G5 94 227 NOR3_X1
X238 204 227 126 134 228 AOI211_X1
X239 11 228 229 NOR2_X1
X240 201 226 229 230 OAI21_X1
X241 223 224 230 G551 NAND3_X1
X242 135 151 199 231 NAND3_X1
X243 199 G5 G2 232 AOI21_X1
X244 231 46 10 233 OAI21_X1
X245 135 142 234 NAND2_X1
X246 125 135 234 G2 235 AOI22_X1
X247 G2 204 236 NAND2_X1
X248 236 235 8 237 OAI21_X1
X249 210 237 238 NAND2_X1
X250 G6 201 232 233 239 OAI211_X1
X251 238 239 G40 45 G552 OAI211_X1
X252 13 G9 3 G503 OAI21_X1
X253 3 G7 13 65 G504 OAI22_X1
X254 5 24 86 126 134 138 G505 OAI33_X1
X255 1 8 59 240 NAND3_X1
X256 240 62 8 G508 OAI21_X1
X257 G9 G6 G510 XOR2_X1
X258 G2 21 G512 XNOR2_X1
X259 172 186 118 102 G12 G518 OAI221_X1
X260 G8 G34 44 G6 241 AOI22_X1
X261 12 71 241 242 NOR3_X1
X262 36 189 G11 243 AOI21_X1
X263 29 G7 G9 244 AOI21_X1
X264 244 243 7 245 AOI21_X1
X265 111 245 246 AND2_X1
X266 16 66 69 246 45 8 247 OAI33_X1
X267 242 247 G542 OR2_X1
X268 128 142 95 248 AOI21_X1
X269 248 135 125 G502 AOI21_X1
X270 G12 77 206 249 NOR3_X1
X271 2 G4 11 14 250 NOR4_X1
X272 249 250 42 G506 AOI21_X1
X273 201 210 G507 OR2_X1
X274 88 90 251 NOR2_X1
X275 G5 251 G509 NOR2_X1
X276 112 9 1 252 OAI21_X1
X277 3 G6 253 NAND2_X1
X278 G6 32 72 253 254 OAI22_X1
X279 G6 252 254 G8 G513 AOI22_X1
X280 45 69 G9 G6 255 AOI211_X1
X281 242 255 244 G34 G514 AOI211_X1
X282 8 G7 71 256 NAND3_X1
X283 7 8 68 257 NOR3_X1
X284 256 164 29 G9 189 258 OAI221_X1
X285 G11 257 258 G515 OAI21_X1
X286 6 82 138 259 AOI21_X1
X287 259 234 8 260 OAI21_X1
X288 260 126 8 261 OAI21_X1
X289 G3 139 261 G1 G516 AOI22_X1
X290 7 90 138 262 AND3_X1
X291 57 262 180 88 G517 AOI211_X1
X292 137 206 23 134 263 OAI211_X1
X293 G1 263 G0 264 AOI21_X1
X294 G2 26 G0 265 OAI21_X1
X295 8 32 69 266 NAND3_X1
X296 266 265 47 267 OAI21_X1
X297 264 267 G519 NOR2_X1
X298 CK G29 G502 dff
X299 CK G30 G503 dff
X300 CK G39 G512 dff
X301 CK G40 G513 dff
X302 CK G41 G514 dff
X303 CK G42 G515 dff
X304 CK G43 G516 dff
X305 CK G44 G517 dff
X306 CK G45 G518 dff
X307 CK G46 G519 dff
X308 CK G31 G504 dff
X309 CK G32 G505 dff
X310 CK G33 G506 dff
X311 CK G34 G507 dff
X312 CK G35 G508 dff
X313 CK G36 G509 dff
X314 CK G37 G510 dff
X315 CK G38 G511 dff

************************
* end of SPICE netlist *
************************

* Anti-Floating Pull-Downs (GMIN)
R_PD_0 96 0 100meg
R_PD_1 177 0 100meg
R_PD_2 187 0 100meg
R_PD_3 157 0 100meg
R_PD_4 G551 0 100meg
R_PD_5 117 0 100meg
R_PD_6 38 0 100meg
R_PD_7 225 0 100meg
R_PD_8 259 0 100meg
R_PD_9 109 0 100meg
R_PD_10 G535 0 100meg
R_PD_11 72 0 100meg
R_PD_12 161 0 100meg
R_PD_13 76 0 100meg
R_PD_14 G7 0 100meg
R_PD_15 211 0 100meg
R_PD_16 G518 0 100meg
R_PD_17 200 0 100meg
R_PD_18 229 0 100meg
R_PD_19 G3 0 100meg
R_PD_20 239 0 100meg
R_PD_21 G516 0 100meg
R_PD_22 102 0 100meg
R_PD_23 52 0 100meg
R_PD_24 127 0 100meg
R_PD_25 43 0 100meg
R_PD_26 242 0 100meg
R_PD_27 135 0 100meg
R_PD_28 222 0 100meg
R_PD_29 61 0 100meg
R_PD_30 215 0 100meg
R_PD_31 48 0 100meg
R_PD_32 228 0 100meg
R_PD_33 106 0 100meg
R_PD_34 58 0 100meg
R_PD_35 230 0 100meg
R_PD_36 260 0 100meg
R_PD_37 10 0 100meg
R_PD_38 G36 0 100meg
R_PD_39 56 0 100meg
R_PD_40 G550 0 100meg
R_PD_41 68 0 100meg
R_PD_42 208 0 100meg
R_PD_43 37 0 100meg
R_PD_44 134 0 100meg
R_PD_45 3 0 100meg
R_PD_46 20 0 100meg
R_PD_47 214 0 100meg
R_PD_48 G505 0 100meg
R_PD_49 165 0 100meg
R_PD_50 180 0 100meg
R_PD_51 142 0 100meg
R_PD_52 151 0 100meg
R_PD_53 17 0 100meg
R_PD_54 G1 0 100meg
R_PD_55 166 0 100meg
R_PD_56 36 0 100meg
R_PD_57 G519 0 100meg
R_PD_58 138 0 100meg
R_PD_59 202 0 100meg
R_PD_60 257 0 100meg
R_PD_61 261 0 100meg
R_PD_62 236 0 100meg
R_PD_63 53 0 100meg
R_PD_64 59 0 100meg
R_PD_65 G508 0 100meg
R_PD_66 113 0 100meg
R_PD_67 128 0 100meg
R_PD_68 125 0 100meg
R_PD_69 G12 0 100meg
R_PD_70 255 0 100meg
R_PD_71 92 0 100meg
R_PD_72 22 0 100meg
R_PD_73 G29 0 100meg
R_PD_74 44 0 100meg
R_PD_75 71 0 100meg
R_PD_76 256 0 100meg
R_PD_77 262 0 100meg
R_PD_78 41 0 100meg
R_PD_79 209 0 100meg
R_PD_80 130 0 100meg
R_PD_81 152 0 100meg
R_PD_82 104 0 100meg
R_PD_83 G5 0 100meg
R_PD_84 111 0 100meg
R_PD_85 237 0 100meg
R_PD_86 243 0 100meg
R_PD_87 31 0 100meg
R_PD_88 Q 0 100meg
R_PD_89 159 0 100meg
R_PD_90 27 0 100meg
R_PD_91 78 0 100meg
R_PD_92 13 0 100meg
R_PD_93 178 0 100meg
R_PD_94 162 0 100meg
R_PD_95 253 0 100meg
R_PD_96 21 0 100meg
R_PD_97 169 0 100meg
R_PD_98 65 0 100meg
R_PD_99 G530 0 100meg
R_PD_100 87 0 100meg
R_PD_101 136 0 100meg
R_PD_102 232 0 100meg
R_PD_103 244 0 100meg
R_PD_104 66 0 100meg
R_PD_105 51 0 100meg
R_PD_106 26 0 100meg
R_PD_107 107 0 100meg
R_PD_108 G46 0 100meg
R_PD_109 1 0 100meg
R_PD_110 100 0 100meg
R_PD_111 235 0 100meg
R_PD_112 116 0 100meg
R_PD_113 267 0 100meg
R_PD_114 144 0 100meg
R_PD_115 89 0 100meg
R_PD_116 153 0 100meg
R_PD_117 121 0 100meg
R_PD_118 149 0 100meg
R_PD_119 97 0 100meg
R_PD_120 G532 0 100meg
R_PD_121 15 0 100meg
R_PD_122 238 0 100meg
R_PD_123 G510 0 100meg
R_PD_124 4 0 100meg
R_PD_125 201 0 100meg
R_PD_126 G539 0 100meg
R_PD_127 7 0 100meg
R_PD_128 G517 0 100meg
R_PD_129 231 0 100meg
R_PD_130 246 0 100meg
R_PD_131 207 0 100meg
R_PD_132 150 0 100meg
R_PD_133 G13 0 100meg
R_PD_134 254 0 100meg
R_PD_135 263 0 100meg
R_PD_136 192 0 100meg
R_PD_137 34 0 100meg
R_PD_138 219 0 100meg
R_PD_139 G38 0 100meg
R_PD_140 241 0 100meg
R_PD_141 G546 0 100meg
R_PD_142 245 0 100meg
R_PD_143 172 0 100meg
R_PD_144 223 0 100meg
R_PD_145 190 0 100meg
R_PD_146 252 0 100meg
R_PD_147 G44 0 100meg
R_PD_148 88 0 100meg
R_PD_149 93 0 100meg
R_PD_150 G504 0 100meg
R_PD_151 G547 0 100meg
R_PD_152 249 0 100meg
R_PD_153 251 0 100meg
R_PD_154 32 0 100meg
R_PD_155 182 0 100meg
R_PD_156 14 0 100meg
R_PD_157 175 0 100meg
R_PD_158 84 0 100meg
R_PD_159 185 0 100meg
R_PD_160 191 0 100meg
R_PD_161 176 0 100meg
R_PD_162 194 0 100meg
R_PD_163 G31 0 100meg
R_PD_164 233 0 100meg
R_PD_165 234 0 100meg
R_PD_166 148 0 100meg
R_PD_167 G511 0 100meg
R_PD_168 60 0 100meg
R_PD_169 266 0 100meg
R_PD_170 55 0 100meg
R_PD_171 39 0 100meg
R_PD_172 18 0 100meg
R_PD_173 179 0 100meg
R_PD_174 126 0 100meg
R_PD_175 158 0 100meg
R_PD_176 D 0 100meg
R_PD_177 137 0 100meg
R_PD_178 23 0 100meg
R_PD_179 30 0 100meg
R_PD_180 G503 0 100meg
R_PD_181 221 0 100meg
R_PD_182 167 0 100meg
R_PD_183 132 0 100meg
R_PD_184 29 0 100meg
R_PD_185 90 0 100meg
R_PD_186 6 0 100meg
R_PD_187 216 0 100meg
R_PD_188 146 0 100meg
R_PD_189 64 0 100meg
R_PD_190 73 0 100meg
R_PD_191 164 0 100meg
R_PD_192 G513 0 100meg
R_PD_193 156 0 100meg
R_PD_194 264 0 100meg
R_PD_195 131 0 100meg
R_PD_196 115 0 100meg
R_PD_197 160 0 100meg
R_PD_198 G33 0 100meg
R_PD_199 186 0 100meg
R_PD_200 147 0 100meg
R_PD_201 74 0 100meg
R_PD_202 247 0 100meg
R_PD_203 46 0 100meg
R_PD_204 198 0 100meg
R_PD_205 170 0 100meg
R_PD_206 173 0 100meg
R_PD_207 124 0 100meg
R_PD_208 240 0 100meg
R_PD_209 8 0 100meg
R_PD_210 G542 0 100meg
R_PD_211 G9 0 100meg
R_PD_212 227 0 100meg
R_PD_213 G40 0 100meg
R_PD_214 99 0 100meg
R_PD_215 265 0 100meg
R_PD_216 199 0 100meg
R_PD_217 G502 0 100meg
R_PD_218 54 0 100meg
R_PD_219 108 0 100meg
R_PD_220 217 0 100meg
R_PD_221 G512 0 100meg
R_PD_222 G549 0 100meg
R_PD_223 112 0 100meg
R_PD_224 G6 0 100meg
R_PD_225 86 0 100meg
R_PD_226 28 0 100meg
R_PD_227 120 0 100meg
R_PD_228 226 0 100meg
R_PD_229 118 0 100meg
R_PD_230 G34 0 100meg
R_PD_231 212 0 100meg
R_PD_232 33 0 100meg
R_PD_233 98 0 100meg
R_PD_234 94 0 100meg
R_PD_235 171 0 100meg
R_PD_236 155 0 100meg
R_PD_237 189 0 100meg
R_PD_238 G37 0 100meg
R_PD_239 G537 0 100meg
R_PD_240 139 0 100meg
R_PD_241 80 0 100meg
R_PD_242 45 0 100meg
R_PD_243 248 0 100meg
R_PD_244 213 0 100meg
R_PD_245 G45 0 100meg
R_PD_246 49 0 100meg
R_PD_247 62 0 100meg
R_PD_248 122 0 100meg
R_PD_249 205 0 100meg
R_PD_250 220 0 100meg
R_PD_251 G35 0 100meg
R_PD_252 203 0 100meg
R_PD_253 143 0 100meg
R_PD_254 67 0 100meg
R_PD_255 5 0 100meg
R_PD_256 101 0 100meg
R_PD_257 174 0 100meg
R_PD_258 258 0 100meg
R_PD_259 69 0 100meg
R_PD_260 G509 0 100meg
R_PD_261 50 0 100meg
R_PD_262 184 0 100meg
R_PD_263 G515 0 100meg
R_PD_264 G32 0 100meg
R_PD_265 110 0 100meg
R_PD_266 119 0 100meg
R_PD_267 181 0 100meg
R_PD_268 24 0 100meg
R_PD_269 57 0 100meg
R_PD_270 9 0 100meg
R_PD_271 G30 0 100meg
R_PD_272 12 0 100meg
R_PD_273 140 0 100meg
R_PD_274 103 0 100meg
R_PD_275 40 0 100meg
R_PD_276 195 0 100meg
R_PD_277 83 0 100meg
R_PD_278 G8 0 100meg
R_PD_279 G11 0 100meg
R_PD_280 210 0 100meg
R_PD_281 2 0 100meg
R_PD_282 G0 0 100meg
R_PD_283 G506 0 100meg
R_PD_284 75 0 100meg
R_PD_285 G4 0 100meg
R_PD_286 141 0 100meg
R_PD_287 82 0 100meg
R_PD_288 105 0 100meg
R_PD_289 G43 0 100meg
R_PD_290 168 0 100meg
R_PD_291 85 0 100meg
R_PD_292 79 0 100meg
R_PD_293 154 0 100meg
R_PD_294 204 0 100meg
R_PD_295 224 0 100meg
R_PD_296 16 0 100meg
R_PD_297 70 0 100meg
R_PD_298 163 0 100meg
R_PD_299 193 0 100meg
R_PD_300 77 0 100meg
R_PD_301 183 0 100meg
R_PD_302 G41 0 100meg
R_PD_303 35 0 100meg
R_PD_304 G2 0 100meg
R_PD_305 188 0 100meg
R_PD_306 114 0 100meg
R_PD_307 145 0 100meg
R_PD_308 206 0 100meg
R_PD_309 CK 0 100meg
R_PD_310 218 0 100meg
R_PD_311 197 0 100meg
R_PD_312 G548 0 100meg
R_PD_313 G507 0 100meg
R_PD_314 G10 0 100meg
R_PD_315 G514 0 100meg
R_PD_316 47 0 100meg
R_PD_317 63 0 100meg
R_PD_318 81 0 100meg
R_PD_319 42 0 100meg
R_PD_320 G42 0 100meg
R_PD_321 123 0 100meg
R_PD_322 25 0 100meg
R_PD_323 196 0 100meg
R_PD_324 19 0 100meg
R_PD_325 250 0 100meg
R_PD_326 129 0 100meg
R_PD_327 95 0 100meg
R_PD_328 G552 0 100meg
R_PD_329 91 0 100meg
R_PD_330 11 0 100meg
R_PD_331 133 0 100meg
R_PD_332 G39 0 100meg

* Transient Simulation Directive
.TRAN 100p 10n
