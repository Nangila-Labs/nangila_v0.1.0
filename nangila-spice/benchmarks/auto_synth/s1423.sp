* Nangila SPICE Auto-Synthesized Netlist
.SUBCKT INV_X1 A Z
M1 Z A 0 0 NMOS W=0.2u L=0.05u
M2 Z A 1 1 PMOS W=0.4u L=0.05u
.ENDS

.SUBCKT NAND2_X1 A1 A2 Z
M1 Z A1 1 1 PMOS W=0.4u L=0.05u
M2 Z A2 1 1 PMOS W=0.4u L=0.05u
M3 Z A1 int 0 NMOS W=0.2u L=0.05u
M4 int A2 0 0 NMOS W=0.2u L=0.05u
.ENDS

.SUBCKT AND2_X1 A1 A2 Z
X1 A1 A2 Z_bar NAND2_X1
X2 Z_bar Z INV_X1
.ENDS

.SUBCKT NOR2_X1 A1 A2 Z
M1 int1 A1 1 1 PMOS W=0.4u L=0.05u
M2 Z A2 int1 1 PMOS W=0.4u L=0.05u
M3 Z A1 0 0 NMOS W=0.2u L=0.05u
M4 Z A2 0 0 NMOS W=0.2u L=0.05u
.ENDS

.SUBCKT OR2_X1 A1 A2 Z
X1 A1 A2 Z_bar NOR2_X1
X2 Z_bar Z INV_X1
.ENDS

.SUBCKT XOR2_X1 A1 A2 Z
X1 A1 A2 int1 AND2_X1
X2 A1 A2 int2 NOR2_X1
X3 int1 int2 int3 NOR2_X1
X4 int3 Z INV_X1
.ENDS

.SUBCKT XNOR2_X1 A B Z
X1 A B Z_int XOR2_X1
X2 Z_int Z INV_X1
.ENDS

.SUBCKT BUF_X1 A Z
X1 A Z_bar INV_X1
X2 Z_bar Z INV_X1
.ENDS

.SUBCKT OAI21_X1 A B C Z
X1 A B C Z_bar AOI21_X1
X2 Z_bar Z INV_X1
.ENDS

.SUBCKT AOI21_X1 A B C Z
M1 Z A int1 1 PMOS W=0.4u L=0.05u
M2 int1 B 1 1 PMOS W=0.4u L=0.05u
M3 Z C 1 1 PMOS W=0.4u L=0.05u
M4 Z A 0 0 NMOS W=0.2u L=0.05u
M5 Z B 0 0 NMOS W=0.2u L=0.05u
M6 Z C 0 0 NMOS W=0.2u L=0.05u
.ENDS

.SUBCKT NAND3_X1 A1 A2 A3 Z
X1 A1 A2 int1 AND2_X1
X2 int1 A3 Z NAND2_X1
.ENDS

.SUBCKT AND3_X1 A1 A2 A3 Z
X1 A1 A2 A3 Z_bar NAND3_X1
X2 Z_bar Z INV_X1
.ENDS

.SUBCKT NOR3_X1 A1 A2 A3 Z
X1 A1 A2 int1 OR2_X1
X2 int1 A3 Z NOR2_X1
.ENDS

.SUBCKT OR3_X1 A1 A2 A3 Z
X1 A1 A2 A3 Z_bar NOR3_X1
X2 Z_bar Z INV_X1
.ENDS

.SUBCKT NAND4_X1 A1 A2 A3 A4 Z
X1 A1 A2 A3 int1 AND3_X1
X2 int1 A4 Z NAND2_X1
.ENDS

.SUBCKT AND4_X1 A1 A2 A3 A4 Z
X1 A1 A2 A3 A4 Z_bar NAND4_X1
X2 Z_bar Z INV_X1
.ENDS

.SUBCKT NOR4_X1 A1 A2 A3 A4 Z
X1 A1 A2 A3 int1 OR3_X1
X2 int1 A4 Z NOR2_X1
.ENDS

.SUBCKT OR4_X1 A1 A2 A3 A4 Z
X1 A1 A2 A3 A4 Z_bar NOR4_X1
X2 Z_bar Z INV_X1
.ENDS

.SUBCKT AOI22_X1 A B C D Z
X1 A B int1 AND2_X1
X2 C D int2 AND2_X1
X3 int1 int2 Z NOR2_X1
.ENDS

.SUBCKT OAI22_X1 A B C D Z
X1 A B int1 OR2_X1
X2 C D int2 OR2_X1
X3 int1 int2 Z NAND2_X1
.ENDS

.SUBCKT AOI211_X1 A B C D Z
X1 A B int1 AND2_X1
X2 int1 C D Z NOR3_X1
.ENDS

.SUBCKT OAI211_X1 A B C D Z
X1 A B int1 OR2_X1
X2 int1 C D Z NAND3_X1
.ENDS

.SUBCKT OAI33_X1 A B C D E F Z
X1 A B C int1 OR3_X1
X2 D E F int2 OR3_X1
X3 int1 int2 Z NAND2_X1
.ENDS

.SUBCKT AOI33_X1 A B C D E F Z
X1 A B C int1 AND3_X1
X2 D E F int2 AND3_X1
X3 int1 int2 Z NOR2_X1
.ENDS

.SUBCKT MUX2_X1 A B S Z
X1 S S_bar INV_X1
X2 A S_bar int1 AND2_X1
X3 B S int2 AND2_X1
X4 int1 int2 Z OR2_X1
.ENDS

.SUBCKT DFF_X1 D C Q QN
X1 D Q_int INV_X1
X2 Q_int Q INV_X1
X3 Q_int QN INV_X1
.ENDS

.SUBCKT DFFR_X1 D C RN Q QN
X1 D Q_int INV_X1
X2 Q_int Q INV_X1
X3 Q_int QN INV_X1
.ENDS

.SUBCKT DFFS_X1 C D Q QN SN
X1 D Q_int INV_X1
X2 Q_int Q INV_X1
X3 Q_int QN INV_X1
.ENDS

.SUBCKT DFFRS_X1 C D Q QN RN SN
X1 D Q_int INV_X1
X2 Q_int Q INV_X1
X3 Q_int QN INV_X1
.ENDS

* Provide VDD power source explicitly
Vvdd 1 0 1.8

* Auto-extracted Inputs:
V_CK CK 0 1.8
V_D D 0 0.0
V_CK CK 0 1.8
V_G0 G0 0 0.0
V_G1 G1 0 1.8
V_G2 G2 0 0.0
V_G3 G3 0 1.8
V_G4 G4 0 0.0
V_G5 G5 0 1.8
V_G6 G6 0 0.0
V_G7 G7 0 1.8
V_G8 G8 0 0.0
V_G9 G9 0 1.8
V_G10 G10 0 0.0
V_G11 G11 0 1.8
V_G12 G12 0 0.0
V_G13 G13 0 1.8
V_G14 G14 0 0.0
V_G15 G15 0 1.8
V_G16 G16 0 0.0

* Yosys Generated Netlist:
* SPICE netlist generated by Yosys 0.62 (git sha1 7326bb7d6641500ecb285c291a54a662cb1e76cf, clang++ 17.0.0 -fPIC -O3)

.SUBCKT dff CK Q D
X0 CK D Q 1 DFF_X1
.ENDS dff

X0 G14 1 INV_X1
X1 G67 2 INV_X1
X2 G68 3 INV_X1
X3 G69 4 INV_X1
X4 G88 5 INV_X1
X5 G351 6 INV_X1
X6 G343 7 INV_X1
X7 G11 8 INV_X1
X8 G35 9 INV_X1
X9 G42 10 INV_X1
X10 G43 11 INV_X1
X11 G49 12 INV_X1
X12 G48 13 INV_X1
X13 G47 14 INV_X1
X14 G12 15 INV_X1
X15 G15 G701BF INV_X1
X16 G59 16 INV_X1
X17 G504 17 INV_X1
X18 G65 18 INV_X1
X19 G71 19 INV_X1
X20 G72 20 INV_X1
X21 G73 21 INV_X1
X22 G84 22 INV_X1
X23 G10 23 INV_X1
X24 G25 24 INV_X1
X25 G28 25 INV_X1
X26 G30 26 INV_X1
X27 G37 27 INV_X1
X28 G53 28 INV_X1
X29 G58 29 INV_X1
X30 G61 30 INV_X1
X31 G66 31 INV_X1
X32 G34 32 INV_X1
X33 G27 33 INV_X1
X34 G36 34 INV_X1
X35 G39 35 INV_X1
X36 G40 36 INV_X1
X37 G74 G79 37 XOR2_X1
X38 G75 G80 38 XOR2_X1
X39 G76 G81 39 XOR2_X1
X40 G77 G82 40 XOR2_X1
X41 37 38 39 40 41 NOR4_X1
X42 G79 G80 G81 G82 42 NOR4_X1
X43 G78 42 43 XNOR2_X1
X44 41 43 44 NAND2_X1
X45 44 45 INV_X1
X46 G83 44 46 OR2_X1
X47 G16 31 47 NAND2_X1
X48 G351 46 47 48 OAI21_X1
X49 48 49 INV_X1
X50 G38 48 50 NOR2_X1
X51 9 G34 G179 51 MUX2_X1
X52 50 51 48 52 AOI21_X1
X53 52 53 INV_X1
X54 G14 G504 52 54 OAI21_X1
X55 54 G438 INV_X1
X56 G70 G67 G69 55 NOR3_X1
X57 3 G72 55 56 OAI21_X1
X58 G69 21 G70 57 OAI21_X1
X59 G68 20 G70 58 OAI21_X1
X60 G67 19 G70 59 OAI21_X1
X61 57 58 G69 21 60 OAI211_X1
X62 56 59 G67 19 61 OAI211_X1
X63 60 61 62 NOR2_X1
X64 G64 62 63 NOR2_X1
X65 1 63 62 17 G441 AOI211_X1
X66 G14 G65 62 64 OAI21_X1
X67 64 G447 INV_X1
X68 G66 62 65 NOR2_X1
X69 1 65 62 18 G451 AOI211_X1
X70 G351 G64 66 NAND2_X1
X71 G351 G8 67 OR2_X1
X72 66 67 68 AND2_X1
X73 G85 66 67 69 AOI21_X1
X74 69 68 22 70 AOI21_X1
X75 G351 G4 71 NOR2_X1
X76 G78 G351 72 AND2_X1
X77 71 72 70 73 AOI21_X1
X78 G46 73 74 AND2_X1
X79 G351 G3 75 NOR2_X1
X80 G77 G351 76 AND2_X1
X81 75 76 70 77 AOI21_X1
X82 G351 G2 78 NOR2_X1
X83 G76 G351 79 AND2_X1
X84 78 79 70 80 AOI21_X1
X85 G45 77 80 G44 81 AOI22_X1
X86 G74 G351 82 AND2_X1
X87 G351 G0 83 NOR2_X1
X88 83 82 70 84 AOI21_X1
X89 10 83 82 70 85 AOI211_X1
X90 G75 G351 86 NAND2_X1
X91 69 86 22 68 87 AOI211_X1
X92 G351 G1 88 NOR2_X1
X93 87 88 89 NOR2_X1
X94 G43 89 90 NOR2_X1
X95 11 87 88 91 OAI21_X1
X96 11 87 88 92 NOR3_X1
X97 91 92 85 80 G44 93 OAI221_X1
X98 G46 73 77 G45 94 OAI22_X1
X99 94 93 81 95 AOI21_X1
X100 74 95 96 NOR2_X1
X101 G24 74 95 97 NOR3_X1
X102 24 G24 74 95 98 NOR4_X1
X103 G26 98 99 NAND2_X1
X104 G26 G28 33 98 100 NAND4_X1
X105 G179 100 101 AND2_X1
X106 26 G29 100 G179 102 AOI211_X1
X107 G31 102 103 AND2_X1
X108 G32 G33 103 104 AND3_X1
X109 G31 G32 G33 102 105 NAND4_X1
X110 G179 G34 105 106 OAI21_X1
X111 49 106 107 NOR2_X1
X112 35 36 106 108 AND3_X1
X113 G41 108 109 AND2_X1
X114 G41 35 36 106 110 NAND4_X1
X115 34 109 7 111 OAI21_X1
X116 27 G36 110 G343 112 AOI211_X1
X117 48 112 G38 113 AOI21_X1
X118 107 113 114 NOR2_X1
X119 G58 114 115 NAND2_X1
X120 16 29 107 113 116 OR4_X1
X121 G343 116 117 NAND2_X1
X122 G53 117 118 NAND2_X1
X123 28 30 116 G343 119 AOI211_X1
X124 G343 G62 120 AND2_X1
X125 G351 G343 116 121 OAI21_X1
X126 121 120 119 122 AOI21_X1
X127 G14 60 61 123 OAI21_X1
X128 123 124 INV_X1
X129 124 122 2 125 OAI21_X1
X130 125 122 2 G459 AOI21_X1
X131 2 3 122 126 NOR3_X1
X132 3 122 2 127 OAI21_X1
X133 124 127 128 NAND2_X1
X134 126 128 G464 NOR2_X1
X135 2 3 4 122 129 NOR4_X1
X136 124 126 G69 130 OAI21_X1
X137 129 130 G469 NOR2_X1
X138 G70 129 131 XNOR2_X1
X139 123 131 G477 NOR2_X1
X140 123 G351 1 132 OAI21_X1
X141 G0 G3 G504 133 MUX2_X1
X142 133 G71 132 G494 MUX2_X1
X143 G1 G4 G504 134 MUX2_X1
X144 134 G72 132 G498 MUX2_X1
X145 G2 G5 G504 135 MUX2_X1
X146 135 G73 132 G503 MUX2_X1
X147 G179 32 105 136 OAI21_X1
X148 50 112 136 48 137 AOI22_X1
X149 45 137 138 NOR2_X1
X150 G74 138 139 AND2_X1
X151 G9 123 G351 140 MUX2_X1
X152 140 141 INV_X1
X153 141 138 G74 142 OAI21_X1
X154 139 142 G526 NOR2_X1
X155 G75 139 143 AND2_X1
X156 141 139 G75 144 OAI21_X1
X157 143 144 G531 NOR2_X1
X158 G75 G76 139 145 AND3_X1
X159 141 143 G76 146 OAI21_X1
X160 145 146 G536 NOR2_X1
X161 G77 145 147 NAND2_X1
X162 141 145 G77 148 OAI21_X1
X163 148 145 G77 G541 AOI21_X1
X164 G78 147 149 XOR2_X1
X165 140 149 G548 NOR2_X1
X166 123 G343 1 150 OAI21_X1
X167 G6 G79 150 G565 MUX2_X1
X168 G7 G80 150 G569 MUX2_X1
X169 G8 G81 150 G573 MUX2_X1
X170 G9 G82 150 G577 MUX2_X1
X171 141 138 G83 151 OAI21_X1
X172 151 53 45 G590 AOI21_X1
X173 G10 G84 150 G608 MUX2_X1
X174 G11 G85 150 G613 MUX2_X1
X175 G14 G13 G657 AND2_X1
X176 G14 G87 G11 152 OAI21_X1
X177 152 G94 G11 G663 AOI21_X1
X178 G14 G87 8 153 OAI21_X1
X179 153 8 5 G669 AOI21_X1
X180 G89 G11 154 NOR2_X1
X181 1 154 G11 5 G675 AOI211_X1
X182 G89 G62 119 155 AND3_X1
X183 G87 32 104 156 NAND3_X1
X184 6 156 100 G94 157 OAI211_X1
X185 155 157 G88 109 G702 AOI211_X1
X186 48 G6 G351 158 OAI21_X1
X187 G351 46 159 AND2_X1
X188 G44 80 84 G42 160 OAI22_X1
X189 160 77 G45 G44 80 161 AOI221_X1
X190 85 90 92 94 162 NOR4_X1
X191 159 161 162 G5 6 163 AOI221_X1
X192 96 163 53 164 OAI21_X1
X193 6 120 G59 7 165 AOI211_X1
X194 165 9 6 166 AOI21_X1
X195 G14 158 166 167 OAI21_X1
X196 167 164 158 G705 AOI21_X1
X197 G14 G11 G94 168 OAI21_X1
X198 168 G11 G89 G707 AOI21_X1
X199 G14 G83 52 70 G713 AND4_X1
X200 G351 124 G727 NOR2_X1
X201 G86 G10 G351 169 OAI21_X1
X202 G657 169 G682 NAND2_X1
X203 G351 23 170 NOR2_X1
X204 G86 G10 G343 171 OAI21_X1
X205 G657 170 171 G687 OAI21_X1
X206 G179 G10 172 NOR2_X1
X207 G86 23 G343 173 OAI21_X1
X208 G657 172 173 G693 OAI21_X1
X209 G23 G22 G15 G328 MUX2_X1
X210 G24 96 174 XNOR2_X1
X211 1 174 G109 NOR2_X1
X212 G14 G25 97 175 OAI21_X1
X213 98 175 G113 NOR2_X1
X214 G14 G26 98 176 OAI21_X1
X215 176 98 G26 G118 AOI21_X1
X216 33 99 177 XNOR2_X1
X217 1 177 G125 NOR2_X1
X218 25 G27 99 178 OAI21_X1
X219 G14 100 178 G129 AND3_X1
X220 G29 101 179 XOR2_X1
X221 1 179 G140 NOR2_X1
X222 26 G29 101 180 OAI21_X1
X223 G14 180 181 NAND2_X1
X224 102 181 G144 NOR2_X1
X225 G14 G31 102 182 OAI21_X1
X226 103 182 G149 NOR2_X1
X227 G14 G32 103 183 OAI21_X1
X228 183 103 G32 G154 AOI21_X1
X229 G33 103 G32 184 AOI21_X1
X230 1 104 184 G159 NOR3_X1
X231 G14 G34 104 185 OAI21_X1
X232 185 104 G34 G166 AOI21_X1
X233 1 G35 G175 NOR2_X1
X234 G343 G36 110 186 NAND3_X1
X235 1 111 186 G189 AOI21_X1
X236 1 112 187 OR2_X1
X237 187 111 27 G193 AOI21_X1
X238 G14 G38 112 188 OAI21_X1
X239 188 112 G38 G198 AOI21_X1
X240 G39 106 189 XNOR2_X1
X241 1 189 G208 NOR2_X1
X242 36 106 35 190 AOI21_X1
X243 108 190 191 NOR2_X1
X244 1 191 G214 NOR2_X1
X245 G14 G41 108 192 OAI21_X1
X246 109 192 G218 NOR2_X1
X247 G7 123 G351 193 MUX2_X1
X248 G50 G49 G48 G47 194 NAND4_X1
X249 G328 194 195 NOR2_X1
X250 10 G328 194 196 NOR3_X1
X251 G42 195 197 NOR2_X1
X252 193 196 197 G237 NOR3_X1
X253 G43 196 198 AND2_X1
X254 G43 196 199 NOR2_X1
X255 193 198 199 G242 NOR3_X1
X256 G44 198 200 AND2_X1
X257 G44 198 201 NOR2_X1
X258 193 200 201 G247 NOR3_X1
X259 G45 200 202 NAND2_X1
X260 G45 200 203 XNOR2_X1
X261 193 203 G252 NOR2_X1
X262 G46 202 204 XOR2_X1
X263 193 204 G260 NOR2_X1
X264 G54 106 205 AND2_X1
X265 G56 205 206 NAND2_X1
X266 G343 206 207 NAND2_X1
X267 G14 G47 207 208 OAI21_X1
X268 208 207 15 G303 AOI21_X1
X269 G14 G48 207 209 OAI21_X1
X270 209 207 14 G309 AOI21_X1
X271 G14 G49 207 210 OAI21_X1
X272 210 207 13 G315 AOI21_X1
X273 G14 G50 207 211 OAI21_X1
X274 211 207 12 G321 AOI21_X1
X275 G50 G49 G48 G15 212 OR4_X1
X276 G22 212 G47 213 OAI21_X1
X277 213 194 G15 G332 OAI21_X1
X278 G14 118 214 NAND2_X1
X279 G51 117 215 AND2_X1
X280 G51 117 216 NOR2_X1
X281 214 215 216 G360 NOR3_X1
X282 G52 215 217 AND2_X1
X283 G52 215 218 NOR2_X1
X284 214 217 218 G365 NOR3_X1
X285 G53 217 219 NOR2_X1
X286 214 219 G373 NOR2_X1
X287 G14 G54 106 220 OAI21_X1
X288 205 220 G379 NOR2_X1
X289 G14 206 221 NAND2_X1
X290 G14 206 205 G55 222 OAI211_X1
X291 222 205 G55 G384 AOI21_X1
X292 G56 205 G55 223 AOI21_X1
X293 221 223 G392 NOR2_X1
X294 G14 115 224 NAND2_X1
X295 G14 115 114 G57 225 OAI211_X1
X296 225 114 G57 G397 AOI21_X1
X297 G58 114 G57 226 AOI21_X1
X298 224 226 G405 NOR2_X1
X299 G14 116 227 NAND2_X1
X300 227 115 16 G408 AOI21_X1
X301 1 119 228 OR2_X1
X302 G53 G60 117 229 NAND3_X1
X303 G60 118 230 XOR2_X1
X304 228 230 G416 NOR2_X1
X305 228 229 30 G424 AOI21_X1
X306 G14 G62 119 231 OAI21_X1
X307 231 119 G62 G427 AOI21_X1
X308 CK G22 G332 dff
X309 CK G23 G328 dff
X310 CK G32 G154 dff
X311 CK G33 G159 dff
X312 CK G34 G166 dff
X313 CK G35 G175 dff
X314 CK G36 G189 dff
X315 CK G37 G193 dff
X316 CK G38 G198 dff
X317 CK G39 G208 dff
X318 CK G40 G214 dff
X319 CK G41 G218 dff
X320 CK G24 G109 dff
X321 CK G42 G237 dff
X322 CK G43 G242 dff
X323 CK G44 G247 dff
X324 CK G45 G252 dff
X325 CK G46 G260 dff
X326 CK G47 G303 dff
X327 CK G48 G309 dff
X328 CK G49 G315 dff
X329 CK G50 G321 dff
X330 CK G51 G360 dff
X331 CK G25 G113 dff
X332 CK G52 G365 dff
X333 CK G53 G373 dff
X334 CK G54 G379 dff
X335 CK G55 G384 dff
X336 CK G56 G392 dff
X337 CK G57 G397 dff
X338 CK G58 G405 dff
X339 CK G59 G408 dff
X340 CK G60 G416 dff
X341 CK G61 G424 dff
X342 CK G26 G118 dff
X343 CK G62 G427 dff
X344 CK G504 G438 dff
X345 CK G64 G441 dff
X346 CK G65 G447 dff
X347 CK G66 G451 dff
X348 CK G67 G459 dff
X349 CK G68 G464 dff
X350 CK G69 G469 dff
X351 CK G70 G477 dff
X352 CK G71 G494 dff
X353 CK G27 G125 dff
X354 CK G72 G498 dff
X355 CK G73 G503 dff
X356 CK G74 G526 dff
X357 CK G75 G531 dff
X358 CK G76 G536 dff
X359 CK G77 G541 dff
X360 CK G78 G548 dff
X361 CK G79 G565 dff
X362 CK G80 G569 dff
X363 CK G81 G573 dff
X364 CK G28 G129 dff
X365 CK G82 G577 dff
X366 CK G83 G590 dff
X367 CK G84 G608 dff
X368 CK G85 G613 dff
X369 CK G86 G657 dff
X370 CK G87 G663 dff
X371 CK G88 G669 dff
X372 CK G89 G675 dff
X373 CK G351 G682 dff
X374 CK G343 G687 dff
X375 CK G29 G140 dff
X376 CK G179 G693 dff
X377 CK G93 G705 dff
X378 CK G94 G707 dff
X379 CK G95 G713 dff
X380 CK G30 G144 dff
X381 CK G31 G149 dff
V0 G343 G347 DC 0
V1 G328 G328BF DC 0
V2 G14 G320 DC 0
V3 G14 G407 DC 0
V4 G14 G426 DC 0
V5 G14 G314 DC 0
V6 G14 G437 DC 0
V7 G14 G440 DC 0
V8 G14 G446 DC 0
V9 G14 G450 DC 0
V10 G14 G108 DC 0
V11 G14 G117 DC 0
V12 G14 G486 DC 0
V13 G14 G112 DC 0
V14 G14 G124 DC 0
V15 G14 G308 DC 0
V16 G14 G128 DC 0
V17 G504 G507 DC 0
V18 G504 G510 DC 0
V19 G14 G139 DC 0
V20 G14 G143 DC 0
V21 G14 G148 DC 0
V22 G14 G153 DC 0
V23 G14 G302 DC 0
V24 G14 G158 DC 0
V25 G14 G165 DC 0
V26 G14 G174 DC 0
V27 G332 G332BF DC 0
V28 G14 G188 DC 0
V29 G14 G192 DC 0
V30 G14 G197 DC 0
V31 G14 G207 DC 0
V32 G351 G617 DC 0
V33 G351 G620 DC 0
V34 G14 G213 DC 0
V35 G351 G623 DC 0
V36 G351 G626 DC 0
V37 G351 G629 DC 0
V38 G504 G63 DC 0
V39 G14 G217 DC 0
V40 G351 G632 DC 0
V41 G351 G635 DC 0
V42 G351 G638 DC 0
V43 G351 G641 DC 0
V44 G351 G644 DC 0
V45 G14 G656 DC 0
V46 G13 G659 DC 0
V47 G14 G662 DC 0
V48 G14 G668 DC 0
V49 G14 G674 DC 0
V50 G11 G678 DC 0
V51 G10 G696 DC 0
V52 G701BF G701 DC 0
V53 G14 G704 DC 0
V54 G14 G706 DC 0
V55 G14 G711 DC 0
V56 G15 G714 DC 0
V57 G6 G715 DC 0
V58 G7 G716 DC 0
V59 G8 G717 DC 0
V60 G9 G718 DC 0
V61 G12 G719 DC 0
V62 G0 G720 DC 0
V63 G1 G721 DC 0
V64 G2 G722 DC 0
V65 G3 G723 DC 0
V66 G4 G724 DC 0
V67 G5 G725 DC 0
V68 G93 G726 DC 0
V69 G16 G728 DC 0
V70 G95 G729 DC 0
V71 G351 G90 DC 0
V72 G343 G91 DC 0
V73 G179 G92 DC 0
V74 G15 II1211 DC 0

************************
* end of SPICE netlist *
************************

* Anti-Floating Pull-Downs (GMIN)
R_PD_0 96 0 100meg
R_PD_1 177 0 100meg
R_PD_2 187 0 100meg
R_PD_3 G328 0 100meg
R_PD_4 157 0 100meg
R_PD_5 117 0 100meg
R_PD_6 38 0 100meg
R_PD_7 225 0 100meg
R_PD_8 109 0 100meg
R_PD_9 72 0 100meg
R_PD_10 G25 0 100meg
R_PD_11 161 0 100meg
R_PD_12 76 0 100meg
R_PD_13 G57 0 100meg
R_PD_14 G7 0 100meg
R_PD_15 G427 0 100meg
R_PD_16 211 0 100meg
R_PD_17 200 0 100meg
R_PD_18 229 0 100meg
R_PD_19 G3 0 100meg
R_PD_20 G252 0 100meg
R_PD_21 102 0 100meg
R_PD_22 52 0 100meg
R_PD_23 127 0 100meg
R_PD_24 G707 0 100meg
R_PD_25 G494 0 100meg
R_PD_26 43 0 100meg
R_PD_27 135 0 100meg
R_PD_28 G109 0 100meg
R_PD_29 G451 0 100meg
R_PD_30 G498 0 100meg
R_PD_31 222 0 100meg
R_PD_32 G54 0 100meg
R_PD_33 G52 0 100meg
R_PD_34 61 0 100meg
R_PD_35 215 0 100meg
R_PD_36 48 0 100meg
R_PD_37 228 0 100meg
R_PD_38 G66 0 100meg
R_PD_39 106 0 100meg
R_PD_40 58 0 100meg
R_PD_41 230 0 100meg
R_PD_42 10 0 100meg
R_PD_43 G36 0 100meg
R_PD_44 G47 0 100meg
R_PD_45 56 0 100meg
R_PD_46 G71 0 100meg
R_PD_47 68 0 100meg
R_PD_48 G73 0 100meg
R_PD_49 208 0 100meg
R_PD_50 37 0 100meg
R_PD_51 134 0 100meg
R_PD_52 3 0 100meg
R_PD_53 20 0 100meg
R_PD_54 G208 0 100meg
R_PD_55 214 0 100meg
R_PD_56 G365 0 100meg
R_PD_57 G193 0 100meg
R_PD_58 165 0 100meg
R_PD_59 180 0 100meg
R_PD_60 G242 0 100meg
R_PD_61 142 0 100meg
R_PD_62 151 0 100meg
R_PD_63 17 0 100meg
R_PD_64 G14 0 100meg
R_PD_65 G53 0 100meg
R_PD_66 G1 0 100meg
R_PD_67 166 0 100meg
R_PD_68 36 0 100meg
R_PD_69 G669 0 100meg
R_PD_70 G441 0 100meg
R_PD_71 138 0 100meg
R_PD_72 202 0 100meg
R_PD_73 53 0 100meg
R_PD_74 59 0 100meg
R_PD_75 113 0 100meg
R_PD_76 G663 0 100meg
R_PD_77 128 0 100meg
R_PD_78 125 0 100meg
R_PD_79 G12 0 100meg
R_PD_80 92 0 100meg
R_PD_81 22 0 100meg
R_PD_82 G29 0 100meg
R_PD_83 44 0 100meg
R_PD_84 71 0 100meg
R_PD_85 G144 0 100meg
R_PD_86 41 0 100meg
R_PD_87 209 0 100meg
R_PD_88 G693 0 100meg
R_PD_89 130 0 100meg
R_PD_90 152 0 100meg
R_PD_91 104 0 100meg
R_PD_92 G5 0 100meg
R_PD_93 111 0 100meg
R_PD_94 31 0 100meg
R_PD_95 G713 0 100meg
R_PD_96 Q 0 100meg
R_PD_97 159 0 100meg
R_PD_98 G321 0 100meg
R_PD_99 27 0 100meg
R_PD_100 G303 0 100meg
R_PD_101 78 0 100meg
R_PD_102 G343 0 100meg
R_PD_103 G22 0 100meg
R_PD_104 13 0 100meg
R_PD_105 G113 0 100meg
R_PD_106 178 0 100meg
R_PD_107 G94 0 100meg
R_PD_108 162 0 100meg
R_PD_109 G459 0 100meg
R_PD_110 21 0 100meg
R_PD_111 169 0 100meg
R_PD_112 65 0 100meg
R_PD_113 87 0 100meg
R_PD_114 136 0 100meg
R_PD_115 66 0 100meg
R_PD_116 51 0 100meg
R_PD_117 26 0 100meg
R_PD_118 G247 0 100meg
R_PD_119 107 0 100meg
R_PD_120 G46 0 100meg
R_PD_121 1 0 100meg
R_PD_122 100 0 100meg
R_PD_123 G28 0 100meg
R_PD_124 G447 0 100meg
R_PD_125 116 0 100meg
R_PD_126 G77 0 100meg
R_PD_127 G166 0 100meg
R_PD_128 G569 0 100meg
R_PD_129 G129 0 100meg
R_PD_130 144 0 100meg
R_PD_131 G705 0 100meg
R_PD_132 89 0 100meg
R_PD_133 153 0 100meg
R_PD_134 121 0 100meg
R_PD_135 149 0 100meg
R_PD_136 97 0 100meg
R_PD_137 15 0 100meg
R_PD_138 4 0 100meg
R_PD_139 G657 0 100meg
R_PD_140 201 0 100meg
R_PD_141 7 0 100meg
R_PD_142 231 0 100meg
R_PD_143 207 0 100meg
R_PD_144 150 0 100meg
R_PD_145 G13 0 100meg
R_PD_146 192 0 100meg
R_PD_147 G95 0 100meg
R_PD_148 G373 0 100meg
R_PD_149 34 0 100meg
R_PD_150 G687 0 100meg
R_PD_151 219 0 100meg
R_PD_152 G56 0 100meg
R_PD_153 G332 0 100meg
R_PD_154 G38 0 100meg
R_PD_155 172 0 100meg
R_PD_156 G198 0 100meg
R_PD_157 223 0 100meg
R_PD_158 190 0 100meg
R_PD_159 G44 0 100meg
R_PD_160 88 0 100meg
R_PD_161 G48 0 100meg
R_PD_162 93 0 100meg
R_PD_163 G504 0 100meg
R_PD_164 G80 0 100meg
R_PD_165 32 0 100meg
R_PD_166 182 0 100meg
R_PD_167 14 0 100meg
R_PD_168 175 0 100meg
R_PD_169 G536 0 100meg
R_PD_170 84 0 100meg
R_PD_171 G69 0 100meg
R_PD_172 G16 0 100meg
R_PD_173 185 0 100meg
R_PD_174 G541 0 100meg
R_PD_175 G59 0 100meg
R_PD_176 191 0 100meg
R_PD_177 G189 0 100meg
R_PD_178 G27 0 100meg
R_PD_179 G260 0 100meg
R_PD_180 176 0 100meg
R_PD_181 G74 0 100meg
R_PD_182 194 0 100meg
R_PD_183 G31 0 100meg
R_PD_184 148 0 100meg
R_PD_185 G469 0 100meg
R_PD_186 60 0 100meg
R_PD_187 55 0 100meg
R_PD_188 G309 0 100meg
R_PD_189 39 0 100meg
R_PD_190 18 0 100meg
R_PD_191 179 0 100meg
R_PD_192 G15 0 100meg
R_PD_193 G405 0 100meg
R_PD_194 126 0 100meg
R_PD_195 158 0 100meg
R_PD_196 D 0 100meg
R_PD_197 G82 0 100meg
R_PD_198 137 0 100meg
R_PD_199 23 0 100meg
R_PD_200 G577 0 100meg
R_PD_201 30 0 100meg
R_PD_202 G503 0 100meg
R_PD_203 G590 0 100meg
R_PD_204 G218 0 100meg
R_PD_205 G62 0 100meg
R_PD_206 167 0 100meg
R_PD_207 221 0 100meg
R_PD_208 132 0 100meg
R_PD_209 G72 0 100meg
R_PD_210 29 0 100meg
R_PD_211 90 0 100meg
R_PD_212 6 0 100meg
R_PD_213 216 0 100meg
R_PD_214 G83 0 100meg
R_PD_215 146 0 100meg
R_PD_216 G379 0 100meg
R_PD_217 G727 0 100meg
R_PD_218 64 0 100meg
R_PD_219 G81 0 100meg
R_PD_220 G531 0 100meg
R_PD_221 73 0 100meg
R_PD_222 164 0 100meg
R_PD_223 G526 0 100meg
R_PD_224 G84 0 100meg
R_PD_225 156 0 100meg
R_PD_226 131 0 100meg
R_PD_227 G159 0 100meg
R_PD_228 G416 0 100meg
R_PD_229 115 0 100meg
R_PD_230 160 0 100meg
R_PD_231 G78 0 100meg
R_PD_232 G33 0 100meg
R_PD_233 186 0 100meg
R_PD_234 G701BF 0 100meg
R_PD_235 G438 0 100meg
R_PD_236 147 0 100meg
R_PD_237 74 0 100meg
R_PD_238 46 0 100meg
R_PD_239 198 0 100meg
R_PD_240 170 0 100meg
R_PD_241 173 0 100meg
R_PD_242 124 0 100meg
R_PD_243 8 0 100meg
R_PD_244 G9 0 100meg
R_PD_245 227 0 100meg
R_PD_246 G40 0 100meg
R_PD_247 99 0 100meg
R_PD_248 199 0 100meg
R_PD_249 54 0 100meg
R_PD_250 108 0 100meg
R_PD_251 G75 0 100meg
R_PD_252 G175 0 100meg
R_PD_253 217 0 100meg
R_PD_254 112 0 100meg
R_PD_255 G6 0 100meg
R_PD_256 86 0 100meg
R_PD_257 G86 0 100meg
R_PD_258 28 0 100meg
R_PD_259 120 0 100meg
R_PD_260 226 0 100meg
R_PD_261 118 0 100meg
R_PD_262 G34 0 100meg
R_PD_263 212 0 100meg
R_PD_264 33 0 100meg
R_PD_265 98 0 100meg
R_PD_266 G125 0 100meg
R_PD_267 94 0 100meg
R_PD_268 171 0 100meg
R_PD_269 155 0 100meg
R_PD_270 189 0 100meg
R_PD_271 G64 0 100meg
R_PD_272 G408 0 100meg
R_PD_273 G23 0 100meg
R_PD_274 G360 0 100meg
R_PD_275 G37 0 100meg
R_PD_276 139 0 100meg
R_PD_277 80 0 100meg
R_PD_278 G351 0 100meg
R_PD_279 45 0 100meg
R_PD_280 G26 0 100meg
R_PD_281 213 0 100meg
R_PD_282 G45 0 100meg
R_PD_283 49 0 100meg
R_PD_284 62 0 100meg
R_PD_285 122 0 100meg
R_PD_286 205 0 100meg
R_PD_287 G79 0 100meg
R_PD_288 G49 0 100meg
R_PD_289 220 0 100meg
R_PD_290 G35 0 100meg
R_PD_291 203 0 100meg
R_PD_292 G214 0 100meg
R_PD_293 143 0 100meg
R_PD_294 67 0 100meg
R_PD_295 G613 0 100meg
R_PD_296 G179 0 100meg
R_PD_297 G88 0 100meg
R_PD_298 G315 0 100meg
R_PD_299 5 0 100meg
R_PD_300 G67 0 100meg
R_PD_301 101 0 100meg
R_PD_302 174 0 100meg
R_PD_303 G397 0 100meg
R_PD_304 G565 0 100meg
R_PD_305 G149 0 100meg
R_PD_306 G93 0 100meg
R_PD_307 69 0 100meg
R_PD_308 G87 0 100meg
R_PD_309 50 0 100meg
R_PD_310 184 0 100meg
R_PD_311 G32 0 100meg
R_PD_312 110 0 100meg
R_PD_313 G140 0 100meg
R_PD_314 119 0 100meg
R_PD_315 181 0 100meg
R_PD_316 24 0 100meg
R_PD_317 G76 0 100meg
R_PD_318 57 0 100meg
R_PD_319 9 0 100meg
R_PD_320 G30 0 100meg
R_PD_321 12 0 100meg
R_PD_322 140 0 100meg
R_PD_323 G70 0 100meg
R_PD_324 G237 0 100meg
R_PD_325 103 0 100meg
R_PD_326 40 0 100meg
R_PD_327 195 0 100meg
R_PD_328 83 0 100meg
R_PD_329 G8 0 100meg
R_PD_330 G11 0 100meg
R_PD_331 G68 0 100meg
R_PD_332 210 0 100meg
R_PD_333 G55 0 100meg
R_PD_334 2 0 100meg
R_PD_335 G573 0 100meg
R_PD_336 G89 0 100meg
R_PD_337 G0 0 100meg
R_PD_338 G58 0 100meg
R_PD_339 75 0 100meg
R_PD_340 G4 0 100meg
R_PD_341 141 0 100meg
R_PD_342 82 0 100meg
R_PD_343 105 0 100meg
R_PD_344 G43 0 100meg
R_PD_345 168 0 100meg
R_PD_346 85 0 100meg
R_PD_347 G464 0 100meg
R_PD_348 79 0 100meg
R_PD_349 154 0 100meg
R_PD_350 G702 0 100meg
R_PD_351 G154 0 100meg
R_PD_352 G85 0 100meg
R_PD_353 204 0 100meg
R_PD_354 224 0 100meg
R_PD_355 16 0 100meg
R_PD_356 70 0 100meg
R_PD_357 163 0 100meg
R_PD_358 193 0 100meg
R_PD_359 77 0 100meg
R_PD_360 183 0 100meg
R_PD_361 G392 0 100meg
R_PD_362 G41 0 100meg
R_PD_363 G477 0 100meg
R_PD_364 35 0 100meg
R_PD_365 G424 0 100meg
R_PD_366 G2 0 100meg
R_PD_367 188 0 100meg
R_PD_368 114 0 100meg
R_PD_369 145 0 100meg
R_PD_370 206 0 100meg
R_PD_371 G51 0 100meg
R_PD_372 CK 0 100meg
R_PD_373 218 0 100meg
R_PD_374 G50 0 100meg
R_PD_375 197 0 100meg
R_PD_376 G548 0 100meg
R_PD_377 G10 0 100meg
R_PD_378 G682 0 100meg
R_PD_379 47 0 100meg
R_PD_380 G675 0 100meg
R_PD_381 G608 0 100meg
R_PD_382 63 0 100meg
R_PD_383 81 0 100meg
R_PD_384 42 0 100meg
R_PD_385 G60 0 100meg
R_PD_386 G42 0 100meg
R_PD_387 G118 0 100meg
R_PD_388 G384 0 100meg
R_PD_389 123 0 100meg
R_PD_390 25 0 100meg
R_PD_391 G65 0 100meg
R_PD_392 196 0 100meg
R_PD_393 19 0 100meg
R_PD_394 129 0 100meg
R_PD_395 95 0 100meg
R_PD_396 G61 0 100meg
R_PD_397 G24 0 100meg
R_PD_398 91 0 100meg
R_PD_399 11 0 100meg
R_PD_400 133 0 100meg
R_PD_401 G39 0 100meg

* Transient Simulation Directive
.TRAN 100p 10n
