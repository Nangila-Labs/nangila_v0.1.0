* Nangila SPICE Auto-Synthesized Netlist
.SUBCKT INV_X1 A Z
M1 Z A 0 0 NMOS W=0.2u L=0.05u
M2 Z A 1 1 PMOS W=0.4u L=0.05u
.ENDS

.SUBCKT NAND2_X1 A1 A2 Z
M1 Z A1 1 1 PMOS W=0.4u L=0.05u
M2 Z A2 1 1 PMOS W=0.4u L=0.05u
M3 Z A1 int 0 NMOS W=0.2u L=0.05u
M4 int A2 0 0 NMOS W=0.2u L=0.05u
.ENDS

.SUBCKT AND2_X1 A1 A2 Z
X1 A1 A2 Z_bar NAND2_X1
X2 Z_bar Z INV_X1
.ENDS

.SUBCKT NOR2_X1 A1 A2 Z
M1 int1 A1 1 1 PMOS W=0.4u L=0.05u
M2 Z A2 int1 1 PMOS W=0.4u L=0.05u
M3 Z A1 0 0 NMOS W=0.2u L=0.05u
M4 Z A2 0 0 NMOS W=0.2u L=0.05u
.ENDS

.SUBCKT OR2_X1 A1 A2 Z
X1 A1 A2 Z_bar NOR2_X1
X2 Z_bar Z INV_X1
.ENDS

.SUBCKT XOR2_X1 A1 A2 Z
X1 A1 A2 int1 AND2_X1
X2 A1 A2 int2 NOR2_X1
X3 int1 int2 int3 NOR2_X1
X4 int3 Z INV_X1
.ENDS

.SUBCKT XNOR2_X1 A B Z
X1 A B Z_int XOR2_X1
X2 Z_int Z INV_X1
.ENDS

.SUBCKT BUF_X1 A Z
X1 A Z_bar INV_X1
X2 Z_bar Z INV_X1
.ENDS

.SUBCKT OAI21_X1 A B C Z
X1 A B C Z_bar AOI21_X1
X2 Z_bar Z INV_X1
.ENDS

.SUBCKT AOI21_X1 A B C Z
M1 Z A int1 1 PMOS W=0.4u L=0.05u
M2 int1 B 1 1 PMOS W=0.4u L=0.05u
M3 Z C 1 1 PMOS W=0.4u L=0.05u
M4 Z A 0 0 NMOS W=0.2u L=0.05u
M5 Z B 0 0 NMOS W=0.2u L=0.05u
M6 Z C 0 0 NMOS W=0.2u L=0.05u
.ENDS

.SUBCKT NAND3_X1 A1 A2 A3 Z
X1 A1 A2 int1 AND2_X1
X2 int1 A3 Z NAND2_X1
.ENDS

.SUBCKT AND3_X1 A1 A2 A3 Z
X1 A1 A2 A3 Z_bar NAND3_X1
X2 Z_bar Z INV_X1
.ENDS

.SUBCKT NOR3_X1 A1 A2 A3 Z
X1 A1 A2 int1 OR2_X1
X2 int1 A3 Z NOR2_X1
.ENDS

.SUBCKT OR3_X1 A1 A2 A3 Z
X1 A1 A2 A3 Z_bar NOR3_X1
X2 Z_bar Z INV_X1
.ENDS

.SUBCKT NAND4_X1 A1 A2 A3 A4 Z
X1 A1 A2 A3 int1 AND3_X1
X2 int1 A4 Z NAND2_X1
.ENDS

.SUBCKT AND4_X1 A1 A2 A3 A4 Z
X1 A1 A2 A3 A4 Z_bar NAND4_X1
X2 Z_bar Z INV_X1
.ENDS

.SUBCKT NOR4_X1 A1 A2 A3 A4 Z
X1 A1 A2 A3 int1 OR3_X1
X2 int1 A4 Z NOR2_X1
.ENDS

.SUBCKT OR4_X1 A1 A2 A3 A4 Z
X1 A1 A2 A3 A4 Z_bar NOR4_X1
X2 Z_bar Z INV_X1
.ENDS

.SUBCKT AOI22_X1 A B C D Z
X1 A B int1 AND2_X1
X2 C D int2 AND2_X1
X3 int1 int2 Z NOR2_X1
.ENDS

.SUBCKT OAI22_X1 A B C D Z
X1 A B int1 OR2_X1
X2 C D int2 OR2_X1
X3 int1 int2 Z NAND2_X1
.ENDS

.SUBCKT AOI211_X1 A B C D Z
X1 A B int1 AND2_X1
X2 int1 C D Z NOR3_X1
.ENDS

.SUBCKT OAI211_X1 A B C D Z
X1 A B int1 OR2_X1
X2 int1 C D Z NAND3_X1
.ENDS

.SUBCKT OAI33_X1 A B C D E F Z
X1 A B C int1 OR3_X1
X2 D E F int2 OR3_X1
X3 int1 int2 Z NAND2_X1
.ENDS

.SUBCKT AOI33_X1 A B C D E F Z
X1 A B C int1 AND3_X1
X2 D E F int2 AND3_X1
X3 int1 int2 Z NOR2_X1
.ENDS

.SUBCKT MUX2_X1 A B S Z
X1 S S_bar INV_X1
X2 A S_bar int1 AND2_X1
X3 B S int2 AND2_X1
X4 int1 int2 Z OR2_X1
.ENDS

.SUBCKT DFF_X1 D C Q QN
X1 D Q_int INV_X1
X2 Q_int Q INV_X1
X3 Q_int QN INV_X1
.ENDS

.SUBCKT DFFR_X1 D C RN Q QN
X1 D Q_int INV_X1
X2 Q_int Q INV_X1
X3 Q_int QN INV_X1
.ENDS

.SUBCKT DFFS_X1 C D Q QN SN
X1 D Q_int INV_X1
X2 Q_int Q INV_X1
X3 Q_int QN INV_X1
.ENDS

.SUBCKT DFFRS_X1 C D Q QN RN SN
X1 D Q_int INV_X1
X2 Q_int Q INV_X1
X3 Q_int QN INV_X1
.ENDS

* Provide VDD power source explicitly
Vvdd 1 0 1.8

* Auto-extracted Inputs:
V_CK CK 0 1.8
V_D D 0 0.0
V_CK CK 0 1.8
V_CLR CLR 0 0.0
V_v6 v6 0 1.8
V_v5 v5 0 0.0
V_v4 v4 0 1.8
V_v3 v3 0 0.0
V_v2 v2 0 1.8
V_v1 v1 0 0.0
V_v0 v0 0 1.8

* Yosys Generated Netlist:
* SPICE netlist generated by Yosys 0.62 (git sha1 7326bb7d6641500ecb285c291a54a662cb1e76cf, clang++ 17.0.0 -fPIC -O3)

.SUBCKT dff CK Q D
X0 CK D Q 1 DFF_X1
.ENDS dff

X0 IIII518 1 INV_X1
X1 v12 2 INV_X1
X2 II143 3 INV_X1
X3 v8 4 INV_X1
X4 C79D 5 INV_X1
X5 v7 6 INV_X1
X6 v2 7 INV_X1
X7 v6 8 INV_X1
X8 v0 9 INV_X1
X9 v1 10 INV_X1
X10 v4 11 INV_X1
X11 CLR 12 INV_X1
X12 v6 10 13 NAND2_X1
X13 II143 v8 14 AND2_X1
X14 II143 v8 15 NAND2_X1
X15 v12 C79D 16 AND2_X1
X16 v12 C79D 17 NAND2_X1
X17 v3 v12 18 AND2_X1
X18 v3 v12 19 NAND2_X1
X19 13 18 20 NAND2_X1
X20 IIII518 C79D 21 AND2_X1
X21 IIII518 C79D 22 NAND2_X1
X22 v7 15 20 22 v13_D_20 NOR4_X1
X23 v4 v5 23 AND2_X1
X24 v4 v5 24 NAND2_X1
X25 IIII518 C79D 25 NOR2_X1
X26 v8 23 25 26 AOI21_X1
X27 1 II143 27 NOR2_X1
X28 v12 v7 28 NOR2_X1
X29 2 6 29 NAND2_X1
X30 v12 II143 30 NOR2_X1
X31 v2 27 28 31 NAND3_X1
X32 II143 v8 32 NOR2_X1
X33 II143 v8 33 OR2_X1
X34 28 32 34 NAND2_X1
X35 IIII518 v8 35 AND2_X1
X36 IIII518 v8 36 NAND2_X1
X37 26 31 34 v13_D_21 AOI21_X1
X38 v3 v6 37 NAND2_X1
X39 1 C79D 38 NOR2_X1
X40 v12 C79D 39 OR2_X1
X41 39 40 INV_X1
X42 v3 v6 28 38 41 NAND4_X1
X43 IIII518 2 42 NOR2_X1
X44 1 v12 43 NAND2_X1
X45 1 v7 v2 16 44 NAND4_X1
X46 15 41 44 v13_D_16 AOI21_X1
X47 v8 C79D 45 NOR2_X1
X48 IIII518 II143 46 NOR2_X1
X49 IIII518 II143 47 OR2_X1
X50 45 46 48 NAND2_X1
X51 v12 24 49 NOR2_X1
X52 v8 v7 50 NOR2_X1
X53 IIII518 v12 51 NOR2_X1
X54 IIII518 v12 52 OR2_X1
X55 23 51 53 NAND2_X1
X56 II143 C79D 54 NOR2_X1
X57 II143 C79D 55 OR2_X1
X58 24 52 55 56 NOR3_X1
X59 50 56 57 NAND2_X1
X60 IIII518 v8 58 NOR2_X1
X61 1 4 59 NAND2_X1
X62 II143 9 60 NAND2_X1
X63 IIII518 3 61 NOR2_X1
X64 v2 36 59 60 62 OAI22_X1
X65 v4 v5 63 NOR2_X1
X66 C79D 62 v5 v4 64 OAI211_X1
X67 57 64 29 v13_D_18 OAI21_X1
X68 II143 8 65 NOR2_X1
X69 1 v12 v6 54 66 NAND4_X1
X70 v12 5 67 NOR2_X1
X71 2 C79D 68 NAND2_X1
X72 C79D v0 69 AND2_X1
X73 C79D v0 70 NAND2_X1
X74 v12 70 71 NOR2_X1
X75 v12 II143 72 AND2_X1
X76 v12 II143 73 NAND2_X1
X77 IIII518 II143 74 NAND2_X1
X78 61 71 72 21 75 AOI22_X1
X79 v8 v7 66 75 v13_D_23 AOI211_X1
X80 v8 C79D 76 AND2_X1
X81 1 v2 77 NOR2_X1
X82 77 78 INV_X1
X83 4 v2 79 NOR2_X1
X84 II143 C79D 80 AND2_X1
X85 II143 C79D 81 NAND2_X1
X86 55 81 v0 82 OAI21_X1
X87 21 79 82 58 83 AOI22_X1
X88 11 v5 29 83 v13_D_15 NOR4_X1
X89 v8 5 84 NOR2_X1
X90 4 C79D 85 NAND2_X1
X91 1 79 84 v0 86 AOI22_X1
X92 v12 3 87 NOR2_X1
X93 2 II143 88 NAND2_X1
X94 v8 v7 89 NAND2_X1
X95 89 81 v8 90 OAI21_X1
X96 90 91 INV_X1
X97 IIII518 2 92 NAND2_X1
X98 3 29 86 91 92 54 v13_D_9 OAI33_X1
X99 v0 24 52 81 93 NOR4_X1
X100 3 C79D 94 NOR2_X1
X101 v12 3 C79D 95 NOR3_X1
X102 1 v6 39 96 NOR3_X1
X103 93 96 21 88 97 AOI211_X1
X104 97 74 39 98 OAI21_X1
X105 v8 39 v1 v3 99 AOI211_X1
X106 17 13 v3 100 AOI21_X1
X107 2 II143 101 NOR2_X1
X108 4 C79D 102 NOR2_X1
X109 v8 5 103 NAND2_X1
X110 99 101 102 v12 104 AOI211_X1
X111 104 105 INV_X1
X112 IIII518 6 100 105 106 OAI211_X1
X113 45 76 23 107 AOI21_X1
X114 v2 43 89 108 NOR3_X1
X115 v8 v7 74 81 109 NAND4_X1
X116 29 78 107 109 51 21 110 OAI33_X1
X117 108 110 50 98 111 AOI211_X1
X118 12 106 111 v13_D_0C AOI21_X1
X119 9 13 112 NOR2_X1
X120 18 21 9 13 113 OAI211_X1
X121 II143 17 114 NOR2_X1
X122 IIII518 C79D v2 2 115 AOI211_X1
X123 II143 17 23 116 AOI21_X1
X124 46 96 115 116 117 NOR4_X1
X125 4 113 117 118 AOI21_X1
X126 v12 4 119 NAND2_X1
X127 119 120 INV_X1
X128 IIII518 81 121 NOR2_X1
X129 27 121 54 v6 122 AOI211_X1
X130 v12 7 58 123 NOR3_X1
X131 3 v8 124 NAND2_X1
X132 1 v8 125 NOR2_X1
X133 15 33 123 126 NAND3_X1
X134 v12 v8 IIII518 127 AOI21_X1
X135 v3 C79D 72 127 128 NOR4_X1
X136 56 128 129 NOR2_X1
X137 126 129 119 122 130 OAI211_X1
X138 6 118 130 131 OAI21_X1
X139 II143 42 132 XNOR2_X1
X140 IIII518 72 133 NOR2_X1
X141 v12 22 134 NOR2_X1
X142 102 132 134 v7 135 AOI22_X1
X143 12 131 135 v13_D_3C AOI21_X1
X144 2 80 136 NOR2_X1
X145 54 v6 v3 137 OAI21_X1
X146 49 82 136 137 138 AOI22_X1
X147 v8 138 139 NOR2_X1
X148 II143 v1 140 NOR2_X1
X149 16 140 141 AND2_X1
X150 II143 v1 17 73 v8 v3 142 OAI33_X1
X151 v2 125 142 143 OAI21_X1
X152 v12 4 144 NOR2_X1
X153 1 95 102 144 145 OR4_X1
X154 143 145 52 124 146 OAI211_X1
X155 6 139 146 147 OAI21_X1
X156 15 68 148 NOR2_X1
X157 v12 3 v1 149 NAND3_X1
X158 2 v8 23 150 NAND3_X1
X159 5 v7 149 150 151 AOI211_X1
X160 7 148 151 152 OAI21_X1
X161 II143 89 43 C79D 153 AOI211_X1
X162 32 67 154 NAND2_X1
X163 68 33 15 155 AOI21_X1
X164 153 155 v7 156 AOI21_X1
X165 2 II143 v7 21 157 NAND4_X1
X166 v3 v8 5 30 158 NAND4_X1
X167 157 158 159 NAND2_X1
X168 108 159 42 102 160 AOI211_X1
X169 152 156 160 161 AND3_X1
X170 12 147 161 v13_D_1C AOI21_X1
X171 1 3 v2 23 162 NOR4_X1
X172 162 36 15 IIII518 68 163 AOI221_X1
X173 II143 5 51 164 NAND3_X1
X174 IIII518 4 80 165 NAND3_X1
X175 164 165 v8 66 166 OAI211_X1
X176 v6 10 18 76 167 NAND4_X1
X177 60 167 53 168 AOI21_X1
X178 14 69 8 v1 169 OAI211_X1
X179 19 48 169 170 AOI21_X1
X180 163 166 168 170 171 NOR4_X1
X181 v7 171 172 OR2_X1
X182 14 51 79 121 173 AOI22_X1
X183 v8 68 103 51 174 OAI22_X1
X184 II143 6 175 NOR2_X1
X185 28 45 65 77 176 NAND4_X1
X186 157 173 176 10 177 OAI211_X1
X187 177 175 174 178 AOI21_X1
X188 12 172 178 v13_D_5C AOI21_X1
X189 v12 24 IIII518 179 AOI21_X1
X190 v2 46 180 NOR2_X1
X191 v3 47 181 NOR2_X1
X192 181 180 179 3 68 182 AOI221_X1
X193 121 27 10 183 AOI21_X1
X194 5 42 125 30 184 AOI22_X1
X195 C79D 73 185 NOR2_X1
X196 19 36 112 183 v12 v8 186 OAI33_X1
X197 94 114 185 IIII518 187 OAI22_X1
X198 187 184 v6 4 182 188 OAI221_X1
X199 6 186 188 189 OAI21_X1
X200 v2 76 190 NAND2_X1
X201 IIII518 6 73 190 191 OR4_X1
X202 14 25 32 C79D 192 AOI22_X1
X203 v12 6 192 193 NOR3_X1
X204 101 102 134 32 194 AOI22_X1
X205 31 191 194 195 NAND3_X1
X206 193 195 196 NOR2_X1
X207 12 189 196 v13_D_4C AOI21_X1
X208 IIII518 2 45 197 AND3_X1
X209 v8 C79D v1 IIII518 198 OAI211_X1
X210 51 198 199 NOR2_X1
X211 3 197 199 200 OAI21_X1
X212 7 164 200 201 AOI21_X1
X213 C79D 9 23 202 NAND3_X1
X214 58 87 114 202 101 203 OAI221_X1
X215 v12 35 81 204 NAND3_X1
X216 IIII518 2 45 140 205 NAND4_X1
X217 IIII518 3 24 76 206 NAND4_X1
X218 1 v6 33 39 207 OR4_X1
X219 204 205 206 207 208 AND4_X1
X220 IIII518 5 72 209 NAND3_X1
X221 158 209 210 AND2_X1
X222 56 79 141 211 AOI21_X1
X223 203 208 210 211 212 NAND4_X1
X224 6 201 212 213 OAI21_X1
X225 IIII518 89 80 v2 214 AOI211_X1
X226 6 61 68 215 NOR3_X1
X227 v12 89 216 NOR2_X1
X228 215 216 217 NOR2_X1
X229 214 215 216 218 OR3_X1
X230 v12 4 8 46 219 NAND4_X1
X231 52 124 219 v7 220 OAI22_X1
X232 v3 v12 103 221 OAI21_X1
X233 55 218 220 221 222 AOI22_X1
X234 12 213 222 v13_D_2C AOI21_X1
X235 40 79 120 IIII518 223 AOI22_X1
X236 39 74 89 223 II143 v7 v13_D_22 OAI33_X1
X237 v3 5 6 224 NAND3_X1
X238 8 36 88 224 225 NOR4_X1
X239 191 219 224 226 OAI21_X1
X240 225 226 v13_D_19 OR2_X1
X241 v8 54 9 C79D 227 AOI211_X1
X242 125 227 37 102 228 AOI211_X1
X243 190 228 24 102 229 OAI211_X1
X244 6 229 v12 230 OAI21_X1
X245 v8 22 74 231 NAND3_X1
X246 154 230 231 v13_D_11 NAND3_X1
X247 v8 v2 22 232 OAI21_X1
X248 232 94 v2 233 AOI21_X1
X249 11 v5 234 NAND2_X1
X250 2 11 v5 235 NAND3_X1
X251 72 233 235 54 236 AOI211_X1
X252 IIII518 6 32 68 237 OAI211_X1
X253 43 54 238 NOR2_X1
X254 238 175 51 38 101 239 AOI221_X1
X255 237 239 4 v7 236 v13_D_6 OAI221_X1
X256 227 94 v2 240 AOI21_X1
X257 IIII518 v7 241 NOR2_X1
X258 IIII518 v7 240 242 NOR3_X1
X259 21 50 243 NOR2_X1
X260 27 61 85 125 243 24 244 OAI33_X1
X261 2 242 244 245 OAI21_X1
X262 2 v7 47 76 246 NAND4_X1
X263 v12 46 190 247 NOR3_X1
X264 IIII518 15 17 248 NOR3_X1
X265 247 248 249 NOR2_X1
X266 v7 102 133 30 250 OAI211_X1
X267 245 246 249 250 v13_D_10 NAND4_X1
X268 39 16 IIII518 251 OAI21_X1
X269 32 67 251 14 252 AOI22_X1
X270 v2 95 253 NAND2_X1
X271 234 84 77 254 OAI21_X1
X272 39 46 88 102 68 IIII518 255 AOI222_X1
X273 253 254 255 256 NAND3_X1
X274 IIII518 16 69 95 257 NOR4_X1
X275 21 51 124 257 v8 v7 258 OAI33_X1
X276 258 256 6 259 AOI21_X1
X277 259 252 6 v13_D_8 OAI21_X1
X278 54 v5 v12 260 OAI21_X1
X279 58 260 136 54 261 OAI211_X1
X280 v7 261 262 NOR2_X1
X281 IIII518 15 33 263 NAND3_X1
X282 225 262 263 215 264 AOI211_X1
X283 v5 81 265 NOR2_X1
X284 79 175 265 50 266 AOI22_X1
X285 v0 52 266 267 OR3_X1
X286 IIII518 6 73 92 175 v5 268 OAI33_X1
X287 C79D 79 268 269 NAND3_X1
X288 264 267 269 v13_D_24 NAND3_X1
X289 v8 25 61 9 270 AOI211_X1
X290 2 3 C79D 7 4 271 OAI221_X1
X291 23 63 270 271 272 NOR4_X1
X292 217 231 272 v7 v13_D_14 OAI211_X1
X293 4 95 114 273 OAI21_X1
X294 253 273 274 NAND2_X1
X295 241 274 275 NAND2_X1
X296 4 v2 22 59 v0 3 276 OAI33_X1
X297 28 234 276 277 NAND3_X1
X298 II143 43 46 v12 278 OAI22_X1
X299 124 134 278 102 279 AOI22_X1
X300 275 277 279 6 v13_D_7 OAI211_X1
X301 144 76 61 C79D 30 280 AOI221_X1
X302 21 70 241 281 AOI21_X1
X303 6 280 281 88 282 OAI22_X1
X304 247 282 v2 283 AOI21_X1
X305 57 283 v13_D_17 NAND2_X1
X306 71 185 23 30 284 AOI211_X1
X307 284 285 INV_X1
X308 3 22 29 286 NOR3_X1
X309 286 285 241 46 67 287 AOI221_X1
X310 249 287 v8 89 v12 v13_D_12 OAI221_X1
X311 61 10 v12 288 OAI21_X1
X312 23 28 232 289 NAND3_X1
X313 288 289 270 290 OAI21_X1
X314 290 76 28 291 OAI21_X1
X315 v1 21 87 292 NAND3_X1
X316 17 46 95 IIII518 293 AOI22_X1
X317 v7 154 293 4 294 OAI211_X1
X318 58 94 114 295 OAI21_X1
X319 6 164 295 296 NAND3_X1
X320 294 296 247 297 OAI21_X1
X321 291 292 297 v13_D_13 NAND3_X1
X322 CK v12 v13_D_5C dff
X323 CK C79D v13_D_4C dff
X324 CK II143 v13_D_3C dff
X325 CK IIII518 v13_D_2C dff
X326 CK v8 v13_D_1C dff
X327 CK v7 v13_D_0C dff
V0 v13_D_11 Av13_D_11B DC 0
V1 v13_D_10 Av13_D_10B DC 0
V2 v13_D_8 Av13_D_8B DC 0
V3 v13_D_7 Av13_D_7B DC 0
V4 v13_D_6 Av13_D_6B DC 0
V5 v13_D_24 Av13_D_24B DC 0
V6 v13_D_23 Av13_D_23B DC 0
V7 v2 C193D DC 0
V8 v13_D_22 Av13_D_22B DC 0
V9 v13_D_21 Av13_D_21B DC 0
V10 v13_D_20 Av13_D_20B DC 0
V11 v13_D_9 Av13_D_9B DC 0
V12 v13_D_19 Av13_D_19B DC 0
V13 v13_D_18 Av13_D_18B DC 0
V14 v13_D_17 Av13_D_17B DC 0
V15 v13_D_16 Av13_D_16B DC 0
V16 v13_D_15 Av13_D_15B DC 0
V17 v13_D_14 Av13_D_14B DC 0
V18 v13_D_13 Av13_D_13B DC 0
V19 v13_D_12 Av13_D_12B DC 0
V20 II143 v10 DC 0
V21 C79D v11 DC 0
V22 IIII518 v9 DC 0

************************
* end of SPICE netlist *
************************

* Anti-Floating Pull-Downs (GMIN)
R_PD_0 96 0 100meg
R_PD_1 177 0 100meg
R_PD_2 187 0 100meg
R_PD_3 157 0 100meg
R_PD_4 275 0 100meg
R_PD_5 117 0 100meg
R_PD_6 CLR 0 100meg
R_PD_7 38 0 100meg
R_PD_8 225 0 100meg
R_PD_9 259 0 100meg
R_PD_10 109 0 100meg
R_PD_11 72 0 100meg
R_PD_12 161 0 100meg
R_PD_13 76 0 100meg
R_PD_14 v0 0 100meg
R_PD_15 211 0 100meg
R_PD_16 200 0 100meg
R_PD_17 229 0 100meg
R_PD_18 239 0 100meg
R_PD_19 102 0 100meg
R_PD_20 52 0 100meg
R_PD_21 127 0 100meg
R_PD_22 v13_D_24 0 100meg
R_PD_23 v13_D_14 0 100meg
R_PD_24 43 0 100meg
R_PD_25 242 0 100meg
R_PD_26 135 0 100meg
R_PD_27 222 0 100meg
R_PD_28 61 0 100meg
R_PD_29 215 0 100meg
R_PD_30 48 0 100meg
R_PD_31 228 0 100meg
R_PD_32 v7 0 100meg
R_PD_33 v13_D_21 0 100meg
R_PD_34 106 0 100meg
R_PD_35 58 0 100meg
R_PD_36 230 0 100meg
R_PD_37 260 0 100meg
R_PD_38 10 0 100meg
R_PD_39 56 0 100meg
R_PD_40 v2 0 100meg
R_PD_41 68 0 100meg
R_PD_42 208 0 100meg
R_PD_43 37 0 100meg
R_PD_44 134 0 100meg
R_PD_45 3 0 100meg
R_PD_46 20 0 100meg
R_PD_47 276 0 100meg
R_PD_48 v12 0 100meg
R_PD_49 214 0 100meg
R_PD_50 165 0 100meg
R_PD_51 v13_D_16 0 100meg
R_PD_52 271 0 100meg
R_PD_53 180 0 100meg
R_PD_54 142 0 100meg
R_PD_55 151 0 100meg
R_PD_56 17 0 100meg
R_PD_57 v13_D_9 0 100meg
R_PD_58 166 0 100meg
R_PD_59 36 0 100meg
R_PD_60 138 0 100meg
R_PD_61 202 0 100meg
R_PD_62 257 0 100meg
R_PD_63 261 0 100meg
R_PD_64 236 0 100meg
R_PD_65 53 0 100meg
R_PD_66 59 0 100meg
R_PD_67 113 0 100meg
R_PD_68 v13_D_2C 0 100meg
R_PD_69 128 0 100meg
R_PD_70 287 0 100meg
R_PD_71 125 0 100meg
R_PD_72 255 0 100meg
R_PD_73 92 0 100meg
R_PD_74 22 0 100meg
R_PD_75 44 0 100meg
R_PD_76 71 0 100meg
R_PD_77 v13_D_12 0 100meg
R_PD_78 256 0 100meg
R_PD_79 262 0 100meg
R_PD_80 41 0 100meg
R_PD_81 209 0 100meg
R_PD_82 130 0 100meg
R_PD_83 152 0 100meg
R_PD_84 104 0 100meg
R_PD_85 111 0 100meg
R_PD_86 237 0 100meg
R_PD_87 277 0 100meg
R_PD_88 243 0 100meg
R_PD_89 31 0 100meg
R_PD_90 v1 0 100meg
R_PD_91 Q 0 100meg
R_PD_92 v13_D_20 0 100meg
R_PD_93 159 0 100meg
R_PD_94 27 0 100meg
R_PD_95 78 0 100meg
R_PD_96 13 0 100meg
R_PD_97 v13_D_0C 0 100meg
R_PD_98 178 0 100meg
R_PD_99 v5 0 100meg
R_PD_100 162 0 100meg
R_PD_101 253 0 100meg
R_PD_102 21 0 100meg
R_PD_103 269 0 100meg
R_PD_104 169 0 100meg
R_PD_105 65 0 100meg
R_PD_106 87 0 100meg
R_PD_107 v3 0 100meg
R_PD_108 280 0 100meg
R_PD_109 136 0 100meg
R_PD_110 232 0 100meg
R_PD_111 244 0 100meg
R_PD_112 66 0 100meg
R_PD_113 51 0 100meg
R_PD_114 v13_D_3C 0 100meg
R_PD_115 26 0 100meg
R_PD_116 279 0 100meg
R_PD_117 107 0 100meg
R_PD_118 C79D 0 100meg
R_PD_119 1 0 100meg
R_PD_120 100 0 100meg
R_PD_121 235 0 100meg
R_PD_122 IIII518 0 100meg
R_PD_123 116 0 100meg
R_PD_124 267 0 100meg
R_PD_125 293 0 100meg
R_PD_126 144 0 100meg
R_PD_127 89 0 100meg
R_PD_128 v13_D_5C 0 100meg
R_PD_129 153 0 100meg
R_PD_130 121 0 100meg
R_PD_131 149 0 100meg
R_PD_132 97 0 100meg
R_PD_133 v13_D_15 0 100meg
R_PD_134 v13_D_6 0 100meg
R_PD_135 15 0 100meg
R_PD_136 238 0 100meg
R_PD_137 4 0 100meg
R_PD_138 201 0 100meg
R_PD_139 7 0 100meg
R_PD_140 231 0 100meg
R_PD_141 246 0 100meg
R_PD_142 207 0 100meg
R_PD_143 150 0 100meg
R_PD_144 254 0 100meg
R_PD_145 v4 0 100meg
R_PD_146 263 0 100meg
R_PD_147 192 0 100meg
R_PD_148 34 0 100meg
R_PD_149 219 0 100meg
R_PD_150 v13_D_17 0 100meg
R_PD_151 241 0 100meg
R_PD_152 290 0 100meg
R_PD_153 245 0 100meg
R_PD_154 172 0 100meg
R_PD_155 223 0 100meg
R_PD_156 190 0 100meg
R_PD_157 252 0 100meg
R_PD_158 88 0 100meg
R_PD_159 93 0 100meg
R_PD_160 249 0 100meg
R_PD_161 251 0 100meg
R_PD_162 32 0 100meg
R_PD_163 182 0 100meg
R_PD_164 14 0 100meg
R_PD_165 175 0 100meg
R_PD_166 v13_D_10 0 100meg
R_PD_167 84 0 100meg
R_PD_168 274 0 100meg
R_PD_169 185 0 100meg
R_PD_170 191 0 100meg
R_PD_171 296 0 100meg
R_PD_172 v8 0 100meg
R_PD_173 176 0 100meg
R_PD_174 295 0 100meg
R_PD_175 194 0 100meg
R_PD_176 233 0 100meg
R_PD_177 234 0 100meg
R_PD_178 148 0 100meg
R_PD_179 60 0 100meg
R_PD_180 266 0 100meg
R_PD_181 55 0 100meg
R_PD_182 39 0 100meg
R_PD_183 v13_D_18 0 100meg
R_PD_184 18 0 100meg
R_PD_185 179 0 100meg
R_PD_186 126 0 100meg
R_PD_187 158 0 100meg
R_PD_188 D 0 100meg
R_PD_189 137 0 100meg
R_PD_190 23 0 100meg
R_PD_191 30 0 100meg
R_PD_192 221 0 100meg
R_PD_193 167 0 100meg
R_PD_194 132 0 100meg
R_PD_195 29 0 100meg
R_PD_196 90 0 100meg
R_PD_197 294 0 100meg
R_PD_198 6 0 100meg
R_PD_199 216 0 100meg
R_PD_200 146 0 100meg
R_PD_201 64 0 100meg
R_PD_202 73 0 100meg
R_PD_203 164 0 100meg
R_PD_204 156 0 100meg
R_PD_205 264 0 100meg
R_PD_206 131 0 100meg
R_PD_207 v6 0 100meg
R_PD_208 115 0 100meg
R_PD_209 160 0 100meg
R_PD_210 186 0 100meg
R_PD_211 147 0 100meg
R_PD_212 74 0 100meg
R_PD_213 247 0 100meg
R_PD_214 46 0 100meg
R_PD_215 198 0 100meg
R_PD_216 v13_D_19 0 100meg
R_PD_217 170 0 100meg
R_PD_218 173 0 100meg
R_PD_219 288 0 100meg
R_PD_220 124 0 100meg
R_PD_221 240 0 100meg
R_PD_222 8 0 100meg
R_PD_223 227 0 100meg
R_PD_224 265 0 100meg
R_PD_225 99 0 100meg
R_PD_226 199 0 100meg
R_PD_227 v13_D_7 0 100meg
R_PD_228 54 0 100meg
R_PD_229 108 0 100meg
R_PD_230 217 0 100meg
R_PD_231 112 0 100meg
R_PD_232 283 0 100meg
R_PD_233 86 0 100meg
R_PD_234 28 0 100meg
R_PD_235 120 0 100meg
R_PD_236 226 0 100meg
R_PD_237 118 0 100meg
R_PD_238 212 0 100meg
R_PD_239 33 0 100meg
R_PD_240 98 0 100meg
R_PD_241 297 0 100meg
R_PD_242 94 0 100meg
R_PD_243 171 0 100meg
R_PD_244 155 0 100meg
R_PD_245 273 0 100meg
R_PD_246 189 0 100meg
R_PD_247 139 0 100meg
R_PD_248 80 0 100meg
R_PD_249 286 0 100meg
R_PD_250 292 0 100meg
R_PD_251 45 0 100meg
R_PD_252 v13_D_11 0 100meg
R_PD_253 248 0 100meg
R_PD_254 213 0 100meg
R_PD_255 v13_D_13 0 100meg
R_PD_256 49 0 100meg
R_PD_257 62 0 100meg
R_PD_258 122 0 100meg
R_PD_259 205 0 100meg
R_PD_260 220 0 100meg
R_PD_261 203 0 100meg
R_PD_262 143 0 100meg
R_PD_263 67 0 100meg
R_PD_264 278 0 100meg
R_PD_265 v13_D_8 0 100meg
R_PD_266 272 0 100meg
R_PD_267 281 0 100meg
R_PD_268 v13_D_22 0 100meg
R_PD_269 291 0 100meg
R_PD_270 5 0 100meg
R_PD_271 101 0 100meg
R_PD_272 174 0 100meg
R_PD_273 258 0 100meg
R_PD_274 69 0 100meg
R_PD_275 50 0 100meg
R_PD_276 184 0 100meg
R_PD_277 110 0 100meg
R_PD_278 119 0 100meg
R_PD_279 181 0 100meg
R_PD_280 24 0 100meg
R_PD_281 57 0 100meg
R_PD_282 9 0 100meg
R_PD_283 12 0 100meg
R_PD_284 140 0 100meg
R_PD_285 v13_D_4C 0 100meg
R_PD_286 v13_D_23 0 100meg
R_PD_287 103 0 100meg
R_PD_288 40 0 100meg
R_PD_289 195 0 100meg
R_PD_290 285 0 100meg
R_PD_291 83 0 100meg
R_PD_292 210 0 100meg
R_PD_293 2 0 100meg
R_PD_294 75 0 100meg
R_PD_295 141 0 100meg
R_PD_296 82 0 100meg
R_PD_297 105 0 100meg
R_PD_298 168 0 100meg
R_PD_299 85 0 100meg
R_PD_300 79 0 100meg
R_PD_301 154 0 100meg
R_PD_302 204 0 100meg
R_PD_303 224 0 100meg
R_PD_304 16 0 100meg
R_PD_305 70 0 100meg
R_PD_306 163 0 100meg
R_PD_307 193 0 100meg
R_PD_308 77 0 100meg
R_PD_309 183 0 100meg
R_PD_310 35 0 100meg
R_PD_311 II143 0 100meg
R_PD_312 188 0 100meg
R_PD_313 114 0 100meg
R_PD_314 145 0 100meg
R_PD_315 206 0 100meg
R_PD_316 CK 0 100meg
R_PD_317 218 0 100meg
R_PD_318 197 0 100meg
R_PD_319 v13_D_1C 0 100meg
R_PD_320 47 0 100meg
R_PD_321 63 0 100meg
R_PD_322 81 0 100meg
R_PD_323 42 0 100meg
R_PD_324 123 0 100meg
R_PD_325 25 0 100meg
R_PD_326 284 0 100meg
R_PD_327 289 0 100meg
R_PD_328 196 0 100meg
R_PD_329 268 0 100meg
R_PD_330 270 0 100meg
R_PD_331 19 0 100meg
R_PD_332 250 0 100meg
R_PD_333 129 0 100meg
R_PD_334 95 0 100meg
R_PD_335 91 0 100meg
R_PD_336 282 0 100meg
R_PD_337 11 0 100meg
R_PD_338 133 0 100meg

* Transient Simulation Directive
.TRAN 100p 10n
