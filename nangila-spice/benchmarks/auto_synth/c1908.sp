* Nangila SPICE Auto-Synthesized Netlist
.SUBCKT INV_X1 A Z
M1 Z A 0 0 NMOS W=0.2u L=0.05u
M2 Z A 1 1 PMOS W=0.4u L=0.05u
.ENDS

.SUBCKT NAND2_X1 A1 A2 Z
M1 Z A1 1 1 PMOS W=0.4u L=0.05u
M2 Z A2 1 1 PMOS W=0.4u L=0.05u
M3 Z A1 int 0 NMOS W=0.2u L=0.05u
M4 int A2 0 0 NMOS W=0.2u L=0.05u
.ENDS

.SUBCKT AND2_X1 A1 A2 Z
X1 A1 A2 Z_bar NAND2_X1
X2 Z_bar Z INV_X1
.ENDS

.SUBCKT NOR2_X1 A1 A2 Z
M1 int1 A1 1 1 PMOS W=0.4u L=0.05u
M2 Z A2 int1 1 PMOS W=0.4u L=0.05u
M3 Z A1 0 0 NMOS W=0.2u L=0.05u
M4 Z A2 0 0 NMOS W=0.2u L=0.05u
.ENDS

.SUBCKT OR2_X1 A1 A2 Z
X1 A1 A2 Z_bar NOR2_X1
X2 Z_bar Z INV_X1
.ENDS

.SUBCKT XOR2_X1 A1 A2 Z
X1 A1 A2 int1 AND2_X1
X2 A1 A2 int2 NOR2_X1
X3 int1 int2 int3 NOR2_X1
X4 int3 Z INV_X1
.ENDS

.SUBCKT XNOR2_X1 A B Z
X1 A B Z_int XOR2_X1
X2 Z_int Z INV_X1
.ENDS

.SUBCKT BUF_X1 A Z
X1 A Z_bar INV_X1
X2 Z_bar Z INV_X1
.ENDS

.SUBCKT OAI21_X1 A B C Z
X1 A B C Z_bar AOI21_X1
X2 Z_bar Z INV_X1
.ENDS

.SUBCKT AOI21_X1 A B C Z
M1 Z A int1 1 PMOS W=0.4u L=0.05u
M2 int1 B 1 1 PMOS W=0.4u L=0.05u
M3 Z C 1 1 PMOS W=0.4u L=0.05u
M4 Z A 0 0 NMOS W=0.2u L=0.05u
M5 Z B 0 0 NMOS W=0.2u L=0.05u
M6 Z C 0 0 NMOS W=0.2u L=0.05u
.ENDS

.SUBCKT NAND3_X1 A1 A2 A3 Z
X1 A1 A2 int1 AND2_X1
X2 int1 A3 Z NAND2_X1
.ENDS

.SUBCKT AND3_X1 A1 A2 A3 Z
X1 A1 A2 A3 Z_bar NAND3_X1
X2 Z_bar Z INV_X1
.ENDS

.SUBCKT NOR3_X1 A1 A2 A3 Z
X1 A1 A2 int1 OR2_X1
X2 int1 A3 Z NOR2_X1
.ENDS

.SUBCKT OR3_X1 A1 A2 A3 Z
X1 A1 A2 A3 Z_bar NOR3_X1
X2 Z_bar Z INV_X1
.ENDS

.SUBCKT NAND4_X1 A1 A2 A3 A4 Z
X1 A1 A2 A3 int1 AND3_X1
X2 int1 A4 Z NAND2_X1
.ENDS

.SUBCKT AND4_X1 A1 A2 A3 A4 Z
X1 A1 A2 A3 A4 Z_bar NAND4_X1
X2 Z_bar Z INV_X1
.ENDS

.SUBCKT NOR4_X1 A1 A2 A3 A4 Z
X1 A1 A2 A3 int1 OR3_X1
X2 int1 A4 Z NOR2_X1
.ENDS

.SUBCKT OR4_X1 A1 A2 A3 A4 Z
X1 A1 A2 A3 A4 Z_bar NOR4_X1
X2 Z_bar Z INV_X1
.ENDS

.SUBCKT AOI22_X1 A B C D Z
X1 A B int1 AND2_X1
X2 C D int2 AND2_X1
X3 int1 int2 Z NOR2_X1
.ENDS

.SUBCKT OAI22_X1 A B C D Z
X1 A B int1 OR2_X1
X2 C D int2 OR2_X1
X3 int1 int2 Z NAND2_X1
.ENDS

.SUBCKT AOI211_X1 A B C D Z
X1 A B int1 AND2_X1
X2 int1 C D Z NOR3_X1
.ENDS

.SUBCKT OAI211_X1 A B C D Z
X1 A B int1 OR2_X1
X2 int1 C D Z NAND3_X1
.ENDS

.SUBCKT OAI33_X1 A B C D E F Z
X1 A B C int1 OR3_X1
X2 D E F int2 OR3_X1
X3 int1 int2 Z NAND2_X1
.ENDS

.SUBCKT AOI33_X1 A B C D E F Z
X1 A B C int1 AND3_X1
X2 D E F int2 AND3_X1
X3 int1 int2 Z NOR2_X1
.ENDS

.SUBCKT MUX2_X1 A B S Z
X1 S S_bar INV_X1
X2 A S_bar int1 AND2_X1
X3 B S int2 AND2_X1
X4 int1 int2 Z OR2_X1
.ENDS

.SUBCKT DFF_X1 D C Q QN
X1 D Q_int INV_X1
X2 Q_int Q INV_X1
X3 Q_int QN INV_X1
.ENDS

.SUBCKT DFFR_X1 D C RN Q QN
X1 D Q_int INV_X1
X2 Q_int Q INV_X1
X3 Q_int QN INV_X1
.ENDS

.SUBCKT DFFS_X1 C D Q QN SN
X1 D Q_int INV_X1
X2 Q_int Q INV_X1
X3 Q_int QN INV_X1
.ENDS

.SUBCKT DFFRS_X1 C D Q QN RN SN
X1 D Q_int INV_X1
X2 Q_int Q INV_X1
X3 Q_int QN INV_X1
.ENDS

* Provide VDD power source explicitly
Vvdd 1 0 1.8

* Auto-extracted Inputs:
V_N1 N1 0 1.8
V_N4 N4 0 0.0
V_N7 N7 0 1.8
V_N10 N10 0 0.0
V_N13 N13 0 1.8
V_N16 N16 0 0.0
V_N19 N19 0 1.8
V_N22 N22 0 0.0
V_N25 N25 0 1.8
V_N28 N28 0 0.0
V_N31 N31 0 1.8
V_N34 N34 0 0.0
V_N37 N37 0 1.8
V_N40 N40 0 0.0
V_N43 N43 0 1.8
V_N46 N46 0 0.0
V_N49 N49 0 1.8
V_N53 N53 0 0.0
V_N56 N56 0 1.8
V_N60 N60 0 0.0
V_N63 N63 0 1.8
V_N66 N66 0 0.0
V_N69 N69 0 1.8
V_N72 N72 0 0.0
V_N76 N76 0 1.8
V_N79 N79 0 0.0
V_N82 N82 0 1.8
V_N85 N85 0 0.0
V_N88 N88 0 1.8
V_N91 N91 0 0.0
V_N94 N94 0 1.8
V_N99 N99 0 0.0
V_N104 N104 0 1.8

* Yosys Generated Netlist:
* SPICE netlist generated by Yosys 0.62 (git sha1 7326bb7d6641500ecb285c291a54a662cb1e76cf, clang++ 17.0.0 -fPIC -O3)

X0 N104 1 INV_X1
X1 N94 2 INV_X1
X2 N99 3 INV_X1
X3 N1 4 INV_X1
X4 N16 N19 5 XNOR2_X1
X5 N13 5 6 XNOR2_X1
X6 N10 N22 7 XNOR2_X1
X7 N1 N4 8 XNOR2_X1
X8 N7 8 9 XNOR2_X1
X9 6 9 10 XNOR2_X1
X10 7 10 11 XNOR2_X1
X11 N63 1 12 NAND2_X1
X12 N25 12 13 XOR2_X1
X13 N43 N28 14 XNOR2_X1
X14 N46 14 15 XNOR2_X1
X15 13 15 16 XNOR2_X1
X16 11 16 17 XOR2_X1
X17 11 16 18 XNOR2_X1
X18 N88 1 19 OR2_X1
X19 N69 N72 20 NAND2_X1
X20 N94 20 21 NAND2_X1
X21 1 N99 20 22 AND3_X1
X22 1 N99 20 23 NAND3_X1
X23 23 21 19 24 OAI21_X1
X24 24 25 INV_X1
X25 N16 N7 26 XNOR2_X1
X26 N22 26 27 XNOR2_X1
X27 1 N69 N56 28 NAND3_X1
X28 N34 14 29 XOR2_X1
X29 28 29 30 XNOR2_X1
X30 27 30 31 XNOR2_X1
X31 2 31 32 AND2_X1
X32 N85 32 33 XNOR2_X1
X33 N85 32 34 XOR2_X1
X34 N25 N40 35 XNOR2_X1
X35 N46 35 36 XNOR2_X1
X36 N22 N13 37 XNOR2_X1
X37 N4 37 38 XNOR2_X1
X38 36 38 39 XNOR2_X1
X39 N104 N72 40 NOR2_X1
X40 N53 40 41 NAND2_X1
X41 N43 N31 42 XNOR2_X1
X42 41 42 43 XNOR2_X1
X43 39 43 44 XNOR2_X1
X44 N94 44 45 NOR2_X1
X45 N82 45 46 XNOR2_X1
X46 N82 45 47 XOR2_X1
X47 24 34 46 48 NAND3_X1
X48 N49 N72 N94 49 OAI21_X1
X49 N94 17 49 50 OR3_X1
X50 49 17 N94 51 OAI21_X1
X51 50 51 52 AND2_X1
X52 N34 N31 53 XOR2_X1
X53 N37 53 54 XNOR2_X1
X54 15 54 55 XNOR2_X1
X55 15 54 56 XOR2_X1
X56 N10 N40 57 XNOR2_X1
X57 N66 1 57 58 AND3_X1
X58 57 1 N66 59 AOI21_X1
X59 9 58 59 60 OR3_X1
X60 9 58 59 61 OAI21_X1
X61 55 60 61 62 AOI21_X1
X62 55 60 61 63 AND3_X1
X63 62 63 64 NOR2_X1
X64 N94 62 63 65 NOR3_X1
X65 N76 65 66 XNOR2_X1
X66 N76 65 67 XOR2_X1
X67 N53 N94 N72 68 OAI21_X1
X68 N69 2 69 NAND2_X1
X69 N60 69 70 NAND2_X1
X70 68 70 71 AND2_X1
X71 67 71 72 NAND2_X1
X72 50 51 67 71 73 NAND4_X1
X73 1 N69 N60 74 NAND3_X1
X74 N37 74 75 XNOR2_X1
X75 36 75 76 XNOR2_X1
X76 N10 N28 77 XNOR2_X1
X77 N19 77 78 XNOR2_X1
X78 76 78 79 XNOR2_X1
X79 N56 69 80 NAND2_X1
X80 2 79 80 81 AND3_X1
X81 80 79 2 82 AOI21_X1
X82 N56 69 79 2 83 AOI22_X1
X83 N56 2 69 79 84 AND4_X1
X84 N49 4 40 85 AND3_X1
X85 4 40 N49 86 AOI21_X1
X86 6 85 86 87 OR3_X1
X87 6 85 86 88 OAI21_X1
X88 56 87 88 89 AOI21_X1
X89 56 87 88 90 AND3_X1
X90 89 90 91 OR2_X1
X91 2 89 90 92 OAI21_X1
X92 N79 92 93 XNOR2_X1
X93 81 82 93 94 OR3_X1
X94 48 73 94 95 NOR3_X1
X95 93 84 83 96 OAI21_X1
X96 50 51 66 71 97 NAND4_X1
X97 24 33 47 98 NAND3_X1
X98 96 97 98 99 NOR3_X1
X99 73 94 98 100 NOR3_X1
X100 48 96 97 101 NOR3_X1
X101 33 46 102 NAND2_X1
X102 24 33 46 103 NAND3_X1
X103 73 96 103 104 NOR3_X1
X104 34 47 105 NAND2_X1
X105 25 94 97 105 106 NOR4_X1
X106 83 84 93 107 OR3_X1
X107 73 103 107 108 NOR3_X1
X108 93 82 81 109 OAI21_X1
X109 97 103 109 110 NOR3_X1
X110 99 108 111 NOR2_X1
X111 95 100 101 110 112 NOR4_X1
X112 104 106 113 NOR2_X1
X113 111 112 113 114 AND3_X1
X114 111 112 113 115 NAND3_X1
X115 N91 1 116 OR2_X1
X116 23 116 21 117 OAI21_X1
X117 117 118 INV_X1
X118 34 46 117 119 NAND3_X1
X119 73 109 119 120 NOR3_X1
X120 52 72 121 NOR2_X1
X121 52 72 96 119 122 NOR4_X1
X122 33 47 117 123 NAND3_X1
X123 52 72 96 123 124 OR4_X1
X124 52 72 107 123 125 NOR4_X1
X125 97 107 123 126 NOR3_X1
X126 102 109 118 127 NOR3_X1
X127 121 127 128 NAND2_X1
X128 73 109 123 129 NOR3_X1
X129 73 96 105 118 130 OR4_X1
X130 122 125 126 129 131 NOR4_X1
X131 120 121 127 132 AOI21_X1
X132 124 130 131 132 133 AND4_X1
X133 124 130 131 132 134 NAND4_X1
X134 2 114 133 135 AOI21_X1
X135 N49 18 135 136 AND3_X1
X136 1 N99 137 NOR2_X1
X137 18 135 N49 138 AOI21_X1
X138 136 137 138 N2886 NOR3_X1
X139 N76 64 135 139 AND3_X1
X140 64 135 N76 140 AOI21_X1
X141 137 139 140 N2887 NOR3_X1
X142 N94 N82 115 134 141 OAI211_X1
X143 44 141 142 XNOR2_X1
X144 137 142 N2888 NOR2_X1
X145 31 135 N85 143 AOI21_X1
X146 N85 31 135 144 AND3_X1
X147 137 143 144 N2889 NOR3_X1
X148 N56 79 135 145 AND3_X1
X149 79 135 N56 146 AOI21_X1
X150 137 145 146 N2890 NOR3_X1
X151 91 135 N79 147 AOI21_X1
X152 N79 91 135 148 AND3_X1
X153 137 147 148 N2899 NOR3_X1
X154 4 104 N2753 XNOR2_X1
X155 N4 100 N2754 XOR2_X1
X156 N7 95 N2755 XOR2_X1
X157 N10 108 N2756 XOR2_X1
X158 N28 120 N2762 XOR2_X1
X159 N43 130 N2767 XNOR2_X1
X160 N46 129 N2768 XOR2_X1
X161 N13 99 N2779 XOR2_X1
X162 N16 101 N2780 XOR2_X1
X163 N19 110 N2781 XOR2_X1
X164 N22 106 N2782 XOR2_X1
X165 N25 126 N2783 XOR2_X1
X166 N31 124 N2784 XNOR2_X1
X167 N34 122 N2785 XOR2_X1
X168 N37 128 N2786 XNOR2_X1
X169 N40 125 N2787 XOR2_X1
X170 68 70 149 XOR2_X1
X171 52 67 150 NOR2_X1
X172 121 149 150 151 AOI21_X1
X173 97 151 152 NAND2_X1
X174 94 102 153 NOR2_X1
X175 23 94 102 154 NOR3_X1
X176 115 134 152 154 155 AOI211_X1
X177 153 109 22 156 AOI21_X1
X178 71 105 150 157 NAND3_X1
X179 156 157 94 102 158 AOI211_X1
X180 N104 158 159 NOR2_X1
X181 159 155 3 N2811 OAI21_X1
X182 1 115 160 NAND2_X1
X183 11 19 161 NAND2_X1
X184 11 161 160 162 MUX2_X1
X185 1 N88 N63 163 AOI21_X1
X186 162 163 N2891 XNOR2_X1
X187 1 N91 N66 164 AOI21_X1
X188 164 134 1 165 AOI21_X1
X189 35 56 166 XNOR2_X1
X190 116 166 167 NAND2_X1
X191 165 167 N2892 XOR2_X1
V0 N1 N1148 DC 0
V1 N94 N283 DC 0
V2 N7 N1004 DC 0
V3 N13 N1151 DC 0
V4 N40 N1241 DC 0
V5 N46 N1240 DC 0
V6 N13 N1152 DC 0
V7 N28 N1153 DC 0
V8 N28 N1154 DC 0
V9 N40 N1238 DC 0
V10 N31 N1156 DC 0
V11 N28 N1005 DC 0
V12 N43 N1006 DC 0
V13 N94 N297 DC 0
V14 N99 N303 DC 0
V15 N104 N316 DC 0
V16 N104 N326 DC 0
V17 N104 N331 DC 0
V18 N1 N343 DC 0
V19 N4 N346 DC 0
V20 N7 N349 DC 0
V21 N10 N352 DC 0
V22 N13 N355 DC 0
V23 N16 N358 DC 0
V24 N19 N361 DC 0
V25 N22 N364 DC 0
V26 N25 N367 DC 0
V27 N28 N370 DC 0
V28 N31 N373 DC 0
V29 N34 N376 DC 0
V30 N37 N379 DC 0
V31 N40 N382 DC 0
V32 N43 N385 DC 0
V33 N46 N388 DC 0
V34 N40 N1228 DC 0
V35 N22 N1003 DC 0
V36 N40 N1225 DC 0
V37 N46 N1161 DC 0
V38 N34 N1223 DC 0
V39 N31 N1222 DC 0
V40 N34 N1007 DC 0
V41 N34 N1220 DC 0
V42 N25 N1219 DC 0
V43 N25 N1217 DC 0
V44 N69 N257 DC 0
V45 N69 N260 DC 0
V46 N43 N1215 DC 0
V47 N16 N1002 DC 0
V48 N43 N1213 DC 0
V49 N16 N1211 DC 0
V50 N16 N1209 DC 0
V51 N4 N1207 DC 0
V52 N25 N1001 DC 0
V53 N19 N1008 DC 0
V54 N28 N1009 DC 0
V55 N10 N888 DC 0
V56 N22 N889 DC 0
V57 N25 N890 DC 0
V58 N40 N891 DC 0
V59 N1 N892 DC 0
V60 N10 N894 DC 0
V61 N37 N895 DC 0
V62 N4 N1205 DC 0
V63 N76 N913 DC 0
V64 N76 N914 DC 0
V65 N79 N915 DC 0
V66 N79 N916 DC 0
V67 N82 N917 DC 0
V68 N82 N918 DC 0
V69 N85 N919 DC 0
V70 N85 N920 DC 0
V71 N1 N1149 DC 0
V72 N7 N938 DC 0
V73 N7 N942 DC 0
V74 N19 N946 DC 0
V75 N19 N950 DC 0
V76 N46 N954 DC 0
V77 N46 N958 DC 0
V78 N37 N968 DC 0
V79 N37 N972 DC 0
V80 N10 N976 DC 0
V81 N10 N980 DC 0
V82 N1 N984 DC 0
V83 N13 N988 DC 0
V84 N22 N989 DC 0
V85 N4 N990 DC 0
V86 N43 N992 DC 0
V87 N31 N993 DC 0
V88 N25 N997 DC 0

************************
* end of SPICE netlist *
************************

* Anti-Floating Pull-Downs (GMIN)
R_PD_0 96 0 100meg
R_PD_1 101 0 100meg
R_PD_2 N2785 0 100meg
R_PD_3 N49 0 100meg
R_PD_4 N76 0 100meg
R_PD_5 157 0 100meg
R_PD_6 162 0 100meg
R_PD_7 N63 0 100meg
R_PD_8 N2892 0 100meg
R_PD_9 117 0 100meg
R_PD_10 N2779 0 100meg
R_PD_11 N88 0 100meg
R_PD_12 38 0 100meg
R_PD_13 21 0 100meg
R_PD_14 69 0 100meg
R_PD_15 N2891 0 100meg
R_PD_16 148 0 100meg
R_PD_17 50 0 100meg
R_PD_18 N2889 0 100meg
R_PD_19 110 0 100meg
R_PD_20 109 0 100meg
R_PD_21 N4 0 100meg
R_PD_22 119 0 100meg
R_PD_23 60 0 100meg
R_PD_24 65 0 100meg
R_PD_25 N53 0 100meg
R_PD_26 72 0 100meg
R_PD_27 N2753 0 100meg
R_PD_28 24 0 100meg
R_PD_29 N34 0 100meg
R_PD_30 55 0 100meg
R_PD_31 57 0 100meg
R_PD_32 87 0 100meg
R_PD_33 9 0 100meg
R_PD_34 N2762 0 100meg
R_PD_35 39 0 100meg
R_PD_36 161 0 100meg
R_PD_37 12 0 100meg
R_PD_38 18 0 100meg
R_PD_39 76 0 100meg
R_PD_40 136 0 100meg
R_PD_41 140 0 100meg
R_PD_42 126 0 100meg
R_PD_43 N72 0 100meg
R_PD_44 158 0 100meg
R_PD_45 137 0 100meg
R_PD_46 23 0 100meg
R_PD_47 N2811 0 100meg
R_PD_48 30 0 100meg
R_PD_49 103 0 100meg
R_PD_50 66 0 100meg
R_PD_51 40 0 100meg
R_PD_52 167 0 100meg
R_PD_53 N31 0 100meg
R_PD_54 51 0 100meg
R_PD_55 132 0 100meg
R_PD_56 N2887 0 100meg
R_PD_57 29 0 100meg
R_PD_58 52 0 100meg
R_PD_59 102 0 100meg
R_PD_60 90 0 100meg
R_PD_61 127 0 100meg
R_PD_62 43 0 100meg
R_PD_63 26 0 100meg
R_PD_64 83 0 100meg
R_PD_65 N13 0 100meg
R_PD_66 6 0 100meg
R_PD_67 135 0 100meg
R_PD_68 107 0 100meg
R_PD_69 146 0 100meg
R_PD_70 N2781 0 100meg
R_PD_71 64 0 100meg
R_PD_72 1 0 100meg
R_PD_73 N19 0 100meg
R_PD_74 100 0 100meg
R_PD_75 61 0 100meg
R_PD_76 2 0 100meg
R_PD_77 116 0 100meg
R_PD_78 73 0 100meg
R_PD_79 164 0 100meg
R_PD_80 N43 0 100meg
R_PD_81 48 0 100meg
R_PD_82 N69 0 100meg
R_PD_83 N2787 0 100meg
R_PD_84 75 0 100meg
R_PD_85 106 0 100meg
R_PD_86 58 0 100meg
R_PD_87 156 0 100meg
R_PD_88 131 0 100meg
R_PD_89 10 0 100meg
R_PD_90 141 0 100meg
R_PD_91 144 0 100meg
R_PD_92 115 0 100meg
R_PD_93 89 0 100meg
R_PD_94 160 0 100meg
R_PD_95 N7 0 100meg
R_PD_96 82 0 100meg
R_PD_97 105 0 100meg
R_PD_98 153 0 100meg
R_PD_99 121 0 100meg
R_PD_100 149 0 100meg
R_PD_101 56 0 100meg
R_PD_102 N46 0 100meg
R_PD_103 97 0 100meg
R_PD_104 N2768 0 100meg
R_PD_105 68 0 100meg
R_PD_106 147 0 100meg
R_PD_107 74 0 100meg
R_PD_108 15 0 100meg
R_PD_109 46 0 100meg
R_PD_110 85 0 100meg
R_PD_111 37 0 100meg
R_PD_112 4 0 100meg
R_PD_113 134 0 100meg
R_PD_114 N2786 0 100meg
R_PD_115 N2890 0 100meg
R_PD_116 3 0 100meg
R_PD_117 N1 0 100meg
R_PD_118 79 0 100meg
R_PD_119 20 0 100meg
R_PD_120 124 0 100meg
R_PD_121 154 0 100meg
R_PD_122 N85 0 100meg
R_PD_123 7 0 100meg
R_PD_124 8 0 100meg
R_PD_125 N56 0 100meg
R_PD_126 16 0 100meg
R_PD_127 70 0 100meg
R_PD_128 99 0 100meg
R_PD_129 150 0 100meg
R_PD_130 163 0 100meg
R_PD_131 N60 0 100meg
R_PD_132 77 0 100meg
R_PD_133 54 0 100meg
R_PD_134 108 0 100meg
R_PD_135 N82 0 100meg
R_PD_136 35 0 100meg
R_PD_137 N2784 0 100meg
R_PD_138 165 0 100meg
R_PD_139 N91 0 100meg
R_PD_140 112 0 100meg
R_PD_141 142 0 100meg
R_PD_142 151 0 100meg
R_PD_143 86 0 100meg
R_PD_144 N79 0 100meg
R_PD_145 17 0 100meg
R_PD_146 114 0 100meg
R_PD_147 N99 0 100meg
R_PD_148 28 0 100meg
R_PD_149 120 0 100meg
R_PD_150 145 0 100meg
R_PD_151 N66 0 100meg
R_PD_152 34 0 100meg
R_PD_153 N10 0 100meg
R_PD_154 36 0 100meg
R_PD_155 N2783 0 100meg
R_PD_156 166 0 100meg
R_PD_157 118 0 100meg
R_PD_158 N40 0 100meg
R_PD_159 138 0 100meg
R_PD_160 33 0 100meg
R_PD_161 N2755 0 100meg
R_PD_162 N2767 0 100meg
R_PD_163 98 0 100meg
R_PD_164 N37 0 100meg
R_PD_165 N104 0 100meg
R_PD_166 N2754 0 100meg
R_PD_167 53 0 100meg
R_PD_168 59 0 100meg
R_PD_169 94 0 100meg
R_PD_170 113 0 100meg
R_PD_171 N16 0 100meg
R_PD_172 47 0 100meg
R_PD_173 128 0 100meg
R_PD_174 155 0 100meg
R_PD_175 63 0 100meg
R_PD_176 81 0 100meg
R_PD_177 N94 0 100meg
R_PD_178 42 0 100meg
R_PD_179 88 0 100meg
R_PD_180 N2886 0 100meg
R_PD_181 N28 0 100meg
R_PD_182 93 0 100meg
R_PD_183 125 0 100meg
R_PD_184 92 0 100meg
R_PD_185 123 0 100meg
R_PD_186 22 0 100meg
R_PD_187 N2899 0 100meg
R_PD_188 25 0 100meg
R_PD_189 139 0 100meg
R_PD_190 80 0 100meg
R_PD_191 44 0 100meg
R_PD_192 45 0 100meg
R_PD_193 71 0 100meg
R_PD_194 N2782 0 100meg
R_PD_195 32 0 100meg
R_PD_196 41 0 100meg
R_PD_197 N2780 0 100meg
R_PD_198 N22 0 100meg
R_PD_199 N2888 0 100meg
R_PD_200 130 0 100meg
R_PD_201 14 0 100meg
R_PD_202 152 0 100meg
R_PD_203 104 0 100meg
R_PD_204 49 0 100meg
R_PD_205 62 0 100meg
R_PD_206 19 0 100meg
R_PD_207 122 0 100meg
R_PD_208 84 0 100meg
R_PD_209 111 0 100meg
R_PD_210 31 0 100meg
R_PD_211 129 0 100meg
R_PD_212 95 0 100meg
R_PD_213 159 0 100meg
R_PD_214 27 0 100meg
R_PD_215 143 0 100meg
R_PD_216 67 0 100meg
R_PD_217 78 0 100meg
R_PD_218 N2756 0 100meg
R_PD_219 N25 0 100meg
R_PD_220 91 0 100meg
R_PD_221 13 0 100meg
R_PD_222 11 0 100meg
R_PD_223 133 0 100meg
R_PD_224 5 0 100meg

* Transient Simulation Directive
.TRAN 100p 10n
