* Nangila SPICE Auto-Synthesized Netlist
.SUBCKT INV_X1 A Z
M1 Z A 0 0 NMOS W=0.2u L=0.05u
M2 Z A 1 1 PMOS W=0.4u L=0.05u
.ENDS

.SUBCKT NAND2_X1 A1 A2 Z
M1 Z A1 1 1 PMOS W=0.4u L=0.05u
M2 Z A2 1 1 PMOS W=0.4u L=0.05u
M3 Z A1 int 0 NMOS W=0.2u L=0.05u
M4 int A2 0 0 NMOS W=0.2u L=0.05u
.ENDS

.SUBCKT AND2_X1 A1 A2 Z
X1 A1 A2 Z_bar NAND2_X1
X2 Z_bar Z INV_X1
.ENDS

.SUBCKT NOR2_X1 A1 A2 Z
M1 int1 A1 1 1 PMOS W=0.4u L=0.05u
M2 Z A2 int1 1 PMOS W=0.4u L=0.05u
M3 Z A1 0 0 NMOS W=0.2u L=0.05u
M4 Z A2 0 0 NMOS W=0.2u L=0.05u
.ENDS

.SUBCKT OR2_X1 A1 A2 Z
X1 A1 A2 Z_bar NOR2_X1
X2 Z_bar Z INV_X1
.ENDS

.SUBCKT XOR2_X1 A1 A2 Z
X1 A1 A2 int1 AND2_X1
X2 A1 A2 int2 NOR2_X1
X3 int1 int2 int3 NOR2_X1
X4 int3 Z INV_X1
.ENDS

.SUBCKT XNOR2_X1 A B Z
X1 A B Z_int XOR2_X1
X2 Z_int Z INV_X1
.ENDS

.SUBCKT BUF_X1 A Z
X1 A Z_bar INV_X1
X2 Z_bar Z INV_X1
.ENDS

.SUBCKT OAI21_X1 A B C Z
X1 A B C Z_bar AOI21_X1
X2 Z_bar Z INV_X1
.ENDS

.SUBCKT AOI21_X1 A B C Z
M1 Z A int1 1 PMOS W=0.4u L=0.05u
M2 int1 B 1 1 PMOS W=0.4u L=0.05u
M3 Z C 1 1 PMOS W=0.4u L=0.05u
M4 Z A 0 0 NMOS W=0.2u L=0.05u
M5 Z B 0 0 NMOS W=0.2u L=0.05u
M6 Z C 0 0 NMOS W=0.2u L=0.05u
.ENDS

.SUBCKT NAND3_X1 A1 A2 A3 Z
X1 A1 A2 int1 AND2_X1
X2 int1 A3 Z NAND2_X1
.ENDS

.SUBCKT AND3_X1 A1 A2 A3 Z
X1 A1 A2 A3 Z_bar NAND3_X1
X2 Z_bar Z INV_X1
.ENDS

.SUBCKT NOR3_X1 A1 A2 A3 Z
X1 A1 A2 int1 OR2_X1
X2 int1 A3 Z NOR2_X1
.ENDS

.SUBCKT OR3_X1 A1 A2 A3 Z
X1 A1 A2 A3 Z_bar NOR3_X1
X2 Z_bar Z INV_X1
.ENDS

.SUBCKT NAND4_X1 A1 A2 A3 A4 Z
X1 A1 A2 A3 int1 AND3_X1
X2 int1 A4 Z NAND2_X1
.ENDS

.SUBCKT AND4_X1 A1 A2 A3 A4 Z
X1 A1 A2 A3 A4 Z_bar NAND4_X1
X2 Z_bar Z INV_X1
.ENDS

.SUBCKT NOR4_X1 A1 A2 A3 A4 Z
X1 A1 A2 A3 int1 OR3_X1
X2 int1 A4 Z NOR2_X1
.ENDS

.SUBCKT OR4_X1 A1 A2 A3 A4 Z
X1 A1 A2 A3 A4 Z_bar NOR4_X1
X2 Z_bar Z INV_X1
.ENDS

.SUBCKT AOI22_X1 A B C D Z
X1 A B int1 AND2_X1
X2 C D int2 AND2_X1
X3 int1 int2 Z NOR2_X1
.ENDS

.SUBCKT OAI22_X1 A B C D Z
X1 A B int1 OR2_X1
X2 C D int2 OR2_X1
X3 int1 int2 Z NAND2_X1
.ENDS

.SUBCKT AOI211_X1 A B C D Z
X1 A B int1 AND2_X1
X2 int1 C D Z NOR3_X1
.ENDS

.SUBCKT OAI211_X1 A B C D Z
X1 A B int1 OR2_X1
X2 int1 C D Z NAND3_X1
.ENDS

.SUBCKT OAI33_X1 A B C D E F Z
X1 A B C int1 OR3_X1
X2 D E F int2 OR3_X1
X3 int1 int2 Z NAND2_X1
.ENDS

.SUBCKT AOI33_X1 A B C D E F Z
X1 A B C int1 AND3_X1
X2 D E F int2 AND3_X1
X3 int1 int2 Z NOR2_X1
.ENDS

.SUBCKT MUX2_X1 A B S Z
X1 S S_bar INV_X1
X2 A S_bar int1 AND2_X1
X3 B S int2 AND2_X1
X4 int1 int2 Z OR2_X1
.ENDS

.SUBCKT DFF_X1 D C Q QN
X1 D Q_int INV_X1
X2 Q_int Q INV_X1
X3 Q_int QN INV_X1
.ENDS

.SUBCKT DFFR_X1 D C RN Q QN
X1 D Q_int INV_X1
X2 Q_int Q INV_X1
X3 Q_int QN INV_X1
.ENDS

.SUBCKT DFFS_X1 C D Q QN SN
X1 D Q_int INV_X1
X2 Q_int Q INV_X1
X3 Q_int QN INV_X1
.ENDS

.SUBCKT DFFRS_X1 C D Q QN RN SN
X1 D Q_int INV_X1
X2 Q_int Q INV_X1
X3 Q_int QN INV_X1
.ENDS

* Provide VDD power source explicitly
Vvdd 1 0 1.8

* Auto-extracted Inputs:
V_CK CK 0 1.8
V_D D 0 0.0
V_CK CK 0 1.8
V_n3065gat n3065gat 0 0.0
V_n3066gat n3066gat 0 1.8
V_n3067gat n3067gat 0 0.0
V_n3068gat n3068gat 0 1.8
V_n3069gat n3069gat 0 0.0
V_n3070gat n3070gat 0 1.8
V_n3071gat n3071gat 0 0.0
V_n3072gat n3072gat 0 1.8
V_n3073gat n3073gat 0 0.0
V_n3074gat n3074gat 0 1.8
V_n3075gat n3075gat 0 0.0
V_n3076gat n3076gat 0 1.8
V_n3077gat n3077gat 0 0.0
V_n3078gat n3078gat 0 1.8
V_n3079gat n3079gat 0 0.0
V_n3080gat n3080gat 0 1.8
V_n3081gat n3081gat 0 0.0
V_n3082gat n3082gat 0 1.8
V_n3083gat n3083gat 0 0.0
V_n3084gat n3084gat 0 1.8
V_n3085gat n3085gat 0 0.0
V_n3086gat n3086gat 0 1.8
V_n3087gat n3087gat 0 0.0
V_n3088gat n3088gat 0 1.8
V_n3089gat n3089gat 0 0.0
V_n3090gat n3090gat 0 1.8
V_n3091gat n3091gat 0 0.0
V_n3092gat n3092gat 0 1.8
V_n3093gat n3093gat 0 0.0
V_n3094gat n3094gat 0 1.8
V_n3095gat n3095gat 0 0.0
V_n3097gat n3097gat 0 1.8
V_n3098gat n3098gat 0 0.0
V_n3099gat n3099gat 0 1.8
V_n3100gat n3100gat 0 0.0

* Yosys Generated Netlist:
* SPICE netlist generated by Yosys 0.62 (git sha1 7326bb7d6641500ecb285c291a54a662cb1e76cf, clang++ 17.0.0 -fPIC -O3)

.SUBCKT dff CK Q D
X0 CK D Q 1 DFF_X1
.ENDS dff

X0 n3090gat 1 INV_X1
X1 II2271 n2201gat INV_X1
X2 II2238 n2443gat INV_X1
X3 II2275 n2205gat INV_X1
X4 II2242 n2284gat INV_X1
X5 n1884gat 2 INV_X1
X6 n2283gat 3 INV_X1
X7 n1595gat 4 INV_X1
X8 II726 5 INV_X1
X9 II687 6 INV_X1
X10 II692 7 INV_X1
X11 II453 8 INV_X1
X12 II414 9 INV_X1
X13 II409 10 INV_X1
X14 n3087gat 11 INV_X1
X15 n3086gat 12 INV_X1
X16 II456 13 INV_X1
X17 II1183 n719gat INV_X1
X18 II1174 n705gat INV_X1
X19 II1178 n718gat INV_X1
X20 II1209 n736gat INV_X1
X21 II1236 n503gat INV_X1
X22 II1416 n596gat INV_X1
X23 II1407 n594gat INV_X1
X24 II1411 n595gat INV_X1
X25 II1472 n682gat INV_X1
X26 II1476 n695gat INV_X1
X27 II2389 n2487gat INV_X1
X28 II2394 n2557gat INV_X1
X29 n2429gat n2482gat INV_X1
X30 n3100gat 14 INV_X1
X31 n2154gat 15 INV_X1
X32 n2536gat n2532gat INV_X1
X33 n2576gat n2574gat INV_X1
X34 II2268 n2353gat INV_X1
X35 n2389gat n2388gat INV_X1
X36 n2494gat n2493gat INV_X1
X37 n2338gat n2337gat INV_X1
X38 n2269gat n2268gat INV_X1
X39 n2550gat n2486gat INV_X1
X40 n2551gat n2553gat INV_X1
X41 n1989gat 16 INV_X1
X42 n1918gat 17 INV_X1
X43 n1988gat 18 INV_X1
X44 n1658gat 19 INV_X1
X45 n2189gat 20 INV_X1
X46 n1311gat 21 INV_X1
X47 n672gat 22 INV_X1
X48 n2591gat n2590gat INV_X1
X49 n1393gat n1392gat INV_X1
X50 n1774gat n1773gat INV_X1
X51 n1315gat n1314gat INV_X1
X52 n2124gat n2123gat INV_X1
X53 n151gat 23 INV_X1
X54 n330gat 24 INV_X1
X55 n326gat 25 INV_X1
X56 n255gat 26 INV_X1
X57 n1339gat 27 INV_X1
X58 n2472gat n2470gat INV_X1
X59 n2319gat 28 INV_X1
X60 n2029gat n2027gat INV_X1
X61 n3094gat 29 INV_X1
X62 n3095gat 30 INV_X1
X63 n1332gat n1330gat INV_X1
X64 n1433gat n1431gat INV_X1
X65 n1363gat n1361gat INV_X1
X66 n2309gat n2307gat INV_X1
X67 n2095gat n2093gat INV_X1
X68 n2176gat n2174gat INV_X1
X69 II3318 n3106gat INV_X1
X70 n2044gat n2042gat INV_X1
X71 n2037gat n2035gat INV_X1
X72 n2025gat n2023gat INV_X1
X73 n2033gat n2031gat INV_X1
X74 n2110gat n2108gat INV_X1
X75 n2121gat n2119gat INV_X1
X76 II3954 n3148gat INV_X1
X77 n2458gat n2456gat INV_X1
X78 n3081gat n3095gat n3093gat n3072gat 31 AOI22_X1
X79 31 n2897gat INV_X1
X80 n3084gat n3083gat 32 NOR2_X1
X81 n3084gat n3083gat 33 XNOR2_X1
X82 n3085gat 33 34 XNOR2_X1
X83 n3087gat n3086gat 35 XOR2_X1
X84 n3088gat n3089gat 36 XNOR2_X1
X85 35 36 37 XNOR2_X1
X86 34 37 n748gat XNOR2_X1
X87 II368 II406 38 XNOR2_X1
X88 II363 38 39 XNOR2_X1
X89 II414 II409 40 NAND2_X1
X90 II414 II409 41 XOR2_X1
X91 II453 II456 42 XNOR2_X1
X92 II359 II461 43 XOR2_X1
X93 42 43 44 XNOR2_X1
X94 41 44 45 XNOR2_X1
X95 39 45 n43gat XNOR2_X1
X96 II687 II692 46 XOR2_X1
X97 II683 46 47 XNOR2_X1
X98 II726 II729 48 XOR2_X1
X99 II651 II734 49 XOR2_X1
X100 48 49 50 XNOR2_X1
X101 II642 II646 51 XOR2_X1
X102 47 51 52 XNOR2_X1
X103 50 52 n55gat XNOR2_X1
X104 n3074gat n3095gat n3093gat n3065gat 53 AOI22_X1
X105 53 n2914gat INV_X1
X106 n3076gat n3095gat n3093gat n3067gat 54 AOI22_X1
X107 54 n2928gat INV_X1
X108 n3075gat n3095gat n3093gat n3066gat 55 AOI22_X1
X109 55 n2927gat INV_X1
X110 n3080gat n3095gat n3093gat n3071gat 56 AOI22_X1
X111 56 n2896gat INV_X1
X112 n3082gat n3095gat n3093gat n3073gat 57 AOI22_X1
X113 57 n2922gat INV_X1
X114 n3077gat n3095gat n3093gat n3068gat 58 AOI22_X1
X115 58 n2894gat INV_X1
X116 n3079gat n3095gat n3093gat n3070gat 59 AOI22_X1
X117 59 n2921gat INV_X1
X118 n3078gat n3095gat n3093gat n3069gat 60 AOI22_X1
X119 60 n2895gat INV_X1
X120 II851 II846 61 XNOR2_X1
X121 II1007 II1011 62 XOR2_X1
X122 61 62 63 XNOR2_X1
X123 II921 II925 64 XOR2_X1
X124 II930 64 65 XNOR2_X1
X125 II842 II1016 66 XNOR2_X1
X126 63 66 67 XNOR2_X1
X127 65 67 n933gat XNOR2_X1
X128 II1209 n625gat 68 XOR2_X1
X129 n621gat 68 69 XNOR2_X1
X130 II1183 II1174 70 XNOR2_X1
X131 n499gat n490gat 71 XOR2_X1
X132 II1178 II1236 72 XNOR2_X1
X133 71 72 73 XNOR2_X1
X134 70 73 74 XNOR2_X1
X135 69 74 n504gat XNOR2_X1
X136 n3093gat II3318 32 75 AND3_X1
X137 n3085gat 12 75 76 NAND3_X1
X138 n3091gat n3092gat 77 NOR2_X1
X139 n3088gat 11 77 78 OR3_X1
X140 76 78 79 NOR2_X1
X141 n3084gat n3085gat n3083gat 80 NOR3_X1
X142 n3086gat n3095gat 80 81 AND3_X1
X143 n3094gat II3318 81 82 NAND3_X1
X144 n3088gat 11 83 NAND2_X1
X145 82 83 84 NOR2_X1
X146 n3065gat 79 84 n3074gat 85 AOI22_X1
X147 85 n2913gat INV_X1
X148 n3067gat 79 84 n3076gat 86 AOI22_X1
X149 86 n2920gat INV_X1
X150 n3066gat 79 84 n3075gat 87 AOI22_X1
X151 87 n2905gat INV_X1
X152 n3068gat 79 84 n3077gat 88 AOI22_X1
X153 88 n2898gat INV_X1
X154 II1353 II1348 89 XNOR2_X1
X155 II1344 II1481 90 XOR2_X1
X156 II1407 II1411 91 XOR2_X1
X157 II1416 91 92 XNOR2_X1
X158 II1472 II1476 93 XNOR2_X1
X159 89 93 94 XNOR2_X1
X160 90 94 95 XNOR2_X1
X161 92 95 n567gat XNOR2_X1
X162 n1879gat n1762gat 96 OR2_X1
X163 n2101gat 96 97 AND2_X1
X164 97 n1858gat INV_X1
X165 n3085gat n3086gat 75 98 NAND3_X1
X166 n3087gat n3095gat II3318 80 99 NAND4_X1
X167 77 83 98 99 82 n3088gat 100 OAI33_X1
X168 n3065gat 100 101 NAND2_X1
X169 II453 II456 102 NAND2_X1
X170 9 II409 n1691gat 102 103 OR4_X1
X171 8 II456 n1691gat 40 104 NOR4_X1
X172 8 II456 n1691gat 40 105 OR4_X1
X173 II453 13 n1691gat 106 OR3_X1
X174 II453 9 13 n1691gat 107 OR4_X1
X175 107 n1945gat INV_X1
X176 103 105 107 n1685gat NAND3_X1
X177 II2389 n2429gat n2532gat n2550gat 108 NAND4_X1
X178 n2482gat n2550gat 109 NAND2_X1
X179 n2487gat 15 n2536gat 110 NAND3_X1
X180 15 108 109 110 111 OAI22_X1
X181 II2238 n2284gat 112 NOR2_X1
X182 II2268 112 113 NAND2_X1
X183 n2201gat n2205gat II2268 112 114 NAND4_X1
X184 II2238 n2284gat II2268 115 NAND3_X1
X185 II2271 II2275 115 116 NOR3_X1
X186 II2275 II2394 116 117 NOR3_X1
X187 n1685gat 111 114 117 118 NAND4_X1
X188 101 118 n2918gat NAND2_X1
X189 n3067gat 100 119 NAND2_X1
X190 118 119 n2952gat NAND2_X1
X191 n3066gat 100 120 NAND2_X1
X192 118 120 n2919gat NAND2_X1
X193 n3071gat 100 121 NAND2_X1
X194 118 121 n2910gat NAND2_X1
X195 n3072gat 100 122 NAND2_X1
X196 118 122 n2907gat NAND2_X1
X197 n3068gat 100 123 NAND2_X1
X198 118 123 n2911gat NAND2_X1
X199 n3070gat 100 124 NAND2_X1
X200 118 124 n2912gat NAND2_X1
X201 n3069gat 100 125 NAND2_X1
X202 118 125 n2909gat NAND2_X1
X203 II1800 II1791 126 XNOR2_X1
X204 II1795 126 127 XNOR2_X1
X205 II1899 II1903 128 XOR2_X1
X206 II1908 128 129 XNOR2_X1
X207 n1225gat n1281gat 130 XNOR2_X1
X208 129 130 131 XNOR2_X1
X209 127 131 132 XNOR2_X1
X210 132 n3116gat INV_X1
X211 n3073gat 100 133 NAND2_X1
X212 118 133 n2908gat NAND2_X1
X213 n1196gat 132 n2971gat XOR2_X1
X214 57 118 n2904gat NAND2_X1
X215 53 118 n2891gat NAND2_X1
X216 54 118 n2903gat NAND2_X1
X217 55 118 n2915gat NAND2_X1
X218 56 118 n2901gat NAND2_X1
X219 31 118 n2890gat NAND2_X1
X220 58 118 n2888gat NAND2_X1
X221 59 118 n2887gat NAND2_X1
X222 60 118 n2886gat NAND2_X1
X223 II2153 II2157 134 XOR2_X1
X224 II2162 134 135 XNOR2_X1
X225 II2049 II2040 136 XNOR2_X1
X226 II2044 136 137 XNOR2_X1
X227 n365gat n560gat 138 XNOR2_X1
X228 137 138 139 XNOR2_X1
X229 135 139 140 XNOR2_X1
X230 n666gat 140 n3010gat XOR2_X1
X231 n2526gat n2464gat II1961 n2599gat 141 NAND4_X1
X232 1 n2522gat n2476gat n2468gat 142 NAND4_X1
X233 141 142 n3016gat OR2_X1
X234 II2238 II2242 143 XNOR2_X1
X235 n2576gat 143 144 XNOR2_X1
X236 II2271 n2205gat 145 NAND2_X1
X237 II2271 n2205gat 146 NOR2_X1
X238 II2271 II2275 147 XNOR2_X1
X239 II2268 147 148 XNOR2_X1
X240 144 148 n2579gat XNOR2_X1
X241 n2338gat n2269gat 149 XNOR2_X1
X242 n2389gat n2494gat 150 XNOR2_X1
X243 149 150 n2646gat XNOR2_X1
X244 II2389 n2536gat 151 XNOR2_X1
X245 II2394 151 152 XNOR2_X1
X246 n2429gat n2550gat 153 XNOR2_X1
X247 n2551gat 153 154 XNOR2_X1
X248 152 154 n2613gat XNOR2_X1
X249 II414 n1691gat 102 155 NOR3_X1
X250 104 155 156 NOR2_X1
X251 n1685gat 155 157 NOR2_X1
X252 157 n1518gat INV_X1
X253 n1495gat n2090gat 158 NOR2_X1
X254 n1884gat n1785gat 159 NOR2_X1
X255 n1631gat n1633gat n1787gat 160 NAND3_X1
X256 n1884gat n1785gat 160 n1713gat NOR3_X1
X257 97 158 n1713gat 161 AND3_X1
X258 n1884gat n1633gat 162 NOR2_X1
X259 n1884gat n1633gat n1785gat 163 NOR3_X1
X260 n1631gat n1787gat 163 164 NAND3_X1
X261 n1858gat 164 165 OR2_X1
X262 n1858gat 158 164 166 NOR3_X1
X263 2 n1633gat 167 NAND2_X1
X264 n1631gat 167 168 NOR2_X1
X265 n1785gat n1787gat n1858gat 168 169 NAND4_X1
X266 n1884gat n1633gat n1785gat n1787gat 170 NOR4_X1
X267 n1631gat 170 171 NAND2_X1
X268 171 n1717gat INV_X1
X269 n1739gat n1858gat 172 NAND2_X1
X270 n1739gat 169 171 172 173 OAI22_X1
X271 161 166 173 174 NOR3_X1
X272 n2189gat II3394 175 NOR2_X1
X273 n2189gat n2134gat II3394 n2178gat 176 OR4_X1
X274 16 n1988gat 177 NOR2_X1
X275 n2283gat 17 178 NAND2_X1
X276 n1658gat 178 179 NOR2_X1
X277 n1658gat 97 178 180 NOR3_X1
X278 3 n1918gat 181 NAND2_X1
X279 n1658gat n1858gat 181 182 NOR3_X1
X280 177 180 182 183 OAI21_X1
X281 174 183 176 n2181gat n2983gat AOI211_X1
X282 II409 107 184 NOR2_X1
X283 II409 n155gat 107 185 NOR3_X1
X284 23 185 186 AND2_X1
X285 n3088gat n3087gat 187 NAND2_X1
X286 187 188 INV_X1
X287 76 77 187 189 NOR3_X1
X288 84 189 190 NOR2_X1
X289 n151gat 185 191 XNOR2_X1
X290 n3067gat 191 190 n3055gat MUX2_X1
X291 n155gat 184 192 XNOR2_X1
X292 n3068gat 192 190 n3056gat MUX2_X1
X293 79 84 193 NOR2_X1
X294 193 194 INV_X1
X295 10 107 195 NOR2_X1
X296 10 n387gat 107 196 NOR3_X1
X297 24 196 197 AND2_X1
X298 24 196 198 XNOR2_X1
X299 n3071gat 79 84 n3080gat 199 AOI22_X1
X300 199 198 194 n3057gat OAI21_X1
X301 n387gat 195 200 XOR2_X1
X302 n3072gat 79 84 n3081gat 201 AOI22_X1
X303 201 200 194 n3058gat OAI21_X1
X304 n387gat 24 n326gat 202 AOI21_X1
X305 10 107 202 203 NOR3_X1
X306 n462gat 203 204 XOR2_X1
X307 n3073gat 79 84 n3082gat 205 AOI22_X1
X308 205 204 194 n3059gat OAI21_X1
X309 25 197 206 AND2_X1
X310 193 197 25 207 OAI21_X1
X311 n3070gat 79 84 n3079gat 208 AOI22_X1
X312 208 207 206 n3060gat OAI21_X1
X313 n383gat 206 209 XOR2_X1
X314 n3069gat 79 84 n3078gat 210 AOI22_X1
X315 210 209 194 n3061gat OAI21_X1
X316 n155gat 23 n255gat 211 AOI21_X1
X317 II409 107 211 212 NOR3_X1
X318 n469gat 212 213 XNOR2_X1
X319 n3073gat 213 190 n3062gat MUX2_X1
X320 26 186 214 NAND2_X1
X321 n255gat 186 215 XNOR2_X1
X322 n3066gat 215 190 n3063gat MUX2_X1
X323 n147gat 214 216 XOR2_X1
X324 n3065gat 216 190 n3064gat MUX2_X1
X325 n3088gat n3086gat 99 217 OR3_X1
X326 n3085gat 12 83 218 NOR3_X1
X327 75 218 219 NAND2_X1
X328 n1884gat n1633gat 217 219 n3151gat NAND4_X1
X329 n1785gat 162 220 XOR2_X1
X330 220 n1691gat II363 n3150gat OAI21_X1
X331 II2238 II2242 n2353gat 221 NAND3_X1
X332 n2443gat II2242 n2353gat 222 NAND3_X1
X333 II2238 II2242 II2268 223 OR3_X1
X334 n2443gat n2284gat II2268 224 NAND3_X1
X335 II2238 n2284gat n2353gat 225 NAND3_X1
X336 II2238 II2242 II2268 226 NAND3_X1
X337 II2044 113 222 II2153 227 OAI22_X1
X338 n365gat 223 224 II2162 226 II2049 228 OAI222_X1
X339 II2040 115 221 II2157 225 n560gat 229 OAI222_X1
X340 227 228 229 230 NOR3_X1
X341 145 230 231 NOR2_X1
X342 II409 140 232 XNOR2_X1
X343 II2271 II2275 226 232 233 NOR4_X1
X344 155 231 233 234 OAI21_X1
X345 n1879gat n1834gat n1767gat 235 AND3_X1
X346 235 n1442gat INV_X1
X347 II646 224 226 II930 236 OAI22_X1
X348 II2271 II2275 237 NAND2_X1
X349 237 238 INV_X1
X350 II1011 225 237 239 NOR3_X1
X351 235 239 240 NOR2_X1
X352 II1236 222 224 II1178 241 OAI22_X1
X353 II1183 115 221 II1174 242 OAI22_X1
X354 241 242 243 OR2_X1
X355 II1411 113 226 II1416 244 OAI22_X1
X356 n1442gat 113 II925 II734 222 245 OAI221_X1
X357 II651 115 221 II642 246 OAI22_X1
X358 236 245 246 247 NOR3_X1
X359 II842 221 222 II1016 248 OAI22_X1
X360 II851 115 224 II846 249 OAI22_X1
X361 248 249 250 OR2_X1
X362 223 n1442gat II1007 251 AOI21_X1
X363 251 n1442gat n682gat 252 OAI21_X1
X364 n2084gat 105 253 AND2_X1
X365 252 253 226 156 113 254 OAI221_X1
X366 254 250 n1442gat 255 AOI21_X1
X367 225 235 II1476 256 AOI21_X1
X368 II1344 221 222 II1481 257 OAI22_X1
X369 II1353 115 224 II1348 258 OAI22_X1
X370 256 257 258 259 OR3_X1
X371 146 n1442gat 244 260 OAI21_X1
X372 146 243 259 238 261 AOI22_X1
X373 237 255 260 247 261 240 262 OAI222_X1
X374 n672gat n2591gat n3106gat 263 NOR3_X1
X375 n1858gat n1442gat 264 NAND2_X1
X376 97 n1442gat 265 NAND2_X1
X377 n1507gat 264 265 n1677gat 266 OAI22_X1
X378 263 266 n1392gat n1389gat 262 267 AOI221_X1
X379 n2579gat 234 267 n3144gat NAND3_X1
X380 n2613gat 234 267 n3143gat NAND3_X1
X381 97 n1685gat 268 NAND2_X1
X382 n1336gat 97 n1685gat 269 NAND3_X1
X383 97 155 n1442gat 270 OAI21_X1
X384 n1747gat 269 270 271 AOI21_X1
X385 27 n1518gat 272 NAND2_X1
X386 n1455gat 97 235 272 273 AOI211_X1
X387 n1806gat 27 97 268 n1393gat n1674gat 274 OAI33_X1
X388 271 273 274 n3141gat OR3_X1
X389 n3086gat n3093gat 275 NAND2_X1
X390 n3093gat 32 n3085gat n3086gat 276 OAI211_X1
X391 n3088gat 276 277 NOR2_X1
X392 277 188 81 278 AOI21_X1
X393 n3086gat n3095gat n3093gat n3085gat 279 AOI22_X1
X394 279 280 INV_X1
X395 n3088gat n3095gat n3093gat n3087gat 281 AOI22_X1
X396 275 30 11 282 OAI21_X1
X397 282 283 INV_X1
X398 279 281 282 284 NAND3_X1
X399 279 281 282 285 OR3_X1
X400 280 281 282 286 NAND3_X1
X401 281 283 287 NOR2_X1
X402 279 287 288 NAND2_X1
X403 280 287 289 NAND2_X1
X404 n672gat 284 288 II925 290 OAI22_X1
X405 II1411 285 286 n365gat 289 II409 291 OAI222_X1
X406 290 291 292 NOR2_X1
X407 n3095gat 80 n3087gat n3086gat 293 OAI211_X1
X408 n3085gat n3087gat n3086gat 294 NAND3_X1
X409 n3088gat n3093gat 294 295 NAND3_X1
X410 293 295 276 296 OAI21_X1
X411 n625gat 285 286 n1225gat 288 II687 297 OAI222_X1
X412 296 297 298 NAND2_X1
X413 298 292 278 n3137gat OAI21_X1
X414 II1416 285 289 II414 299 OAI22_X1
X415 n560gat 286 288 II930 300 OAI22_X1
X416 299 300 301 NOR2_X1
X417 n621gat 285 286 n1281gat 288 II692 302 OAI222_X1
X418 296 302 303 NAND2_X1
X419 303 301 278 n3136gat OAI21_X1
X420 II2153 286 288 II1007 304 OAI22_X1
X421 II1472 285 289 II453 305 OAI22_X1
X422 304 305 306 NOR2_X1
X423 n499gat 285 286 II1899 288 II726 307 OAI222_X1
X424 296 307 308 NAND2_X1
X425 308 306 278 n3135gat OAI21_X1
X426 II1011 288 289 II456 309 OAI22_X1
X427 II1476 285 286 II2157 310 OAI22_X1
X428 309 310 311 NOR2_X1
X429 n490gat 285 286 II1903 288 II729 312 OAI222_X1
X430 296 312 313 NAND2_X1
X431 313 311 278 n3134gat OAI21_X1
X432 II2162 286 288 II1016 314 OAI22_X1
X433 II1481 285 289 II461 315 OAI22_X1
X434 314 315 316 NOR2_X1
X435 II1236 285 286 II1908 288 II734 317 OAI222_X1
X436 296 317 318 NAND2_X1
X437 318 316 278 n3133gat OAI21_X1
X438 II1344 285 286 II2040 319 OAI22_X1
X439 II842 288 289 II359 320 OAI22_X1
X440 319 320 321 NOR2_X1
X441 II1174 285 286 II1791 288 II642 322 OAI222_X1
X442 296 322 323 NAND2_X1
X443 323 321 278 n3132gat OAI21_X1
X444 II1348 285 286 II2044 324 OAI22_X1
X445 II846 288 289 II363 325 OAI22_X1
X446 324 325 326 NOR2_X1
X447 II1178 285 286 II1795 288 II646 327 OAI222_X1
X448 296 327 328 NAND2_X1
X449 328 326 278 n3131gat OAI21_X1
X450 II2049 286 288 II851 329 OAI22_X1
X451 II1353 285 289 II368 330 OAI22_X1
X452 329 330 331 NOR2_X1
X453 II1183 285 286 II1800 288 II651 332 OAI222_X1
X454 296 332 333 NAND2_X1
X455 333 331 278 n3130gat OAI21_X1
X456 280 281 283 334 NAND3_X1
X457 334 284 22 II406 289 335 OAI221_X1
X458 II1407 285 286 140 288 II921 336 OAI222_X1
X459 335 336 337 NOR2_X1
X460 II1209 285 286 132 288 II683 338 OAI222_X1
X461 296 338 339 NAND2_X1
X462 339 337 278 n3129gat OAI21_X1
X463 n2646gat 293 337 n3125gat OAI21_X1
X464 n2971gat 292 293 n3124gat OAI21_X1
X465 n3010gat 293 301 n3123gat OAI21_X1
X466 n504gat 293 306 n3122gat OAI21_X1
X467 n567gat 293 311 n3121gat OAI21_X1
X468 n55gat 293 316 n3120gat OAI21_X1
X469 n933gat 293 321 n3119gat OAI21_X1
X470 n43gat 293 326 n3118gat OAI21_X1
X471 n748gat 293 331 n3117gat OAI21_X1
X472 20 II3394 340 NOR2_X1
X473 n1281gat n2189gat II3394 n3114gat NAND3_X1
X474 n2134gat 175 341 XOR2_X1
X475 II1899 341 n3113gat NAND2_X1
X476 n2283gat II1908 n1918gat n3111gat NAND3_X1
X477 n2283gat n1918gat 342 NOR2_X1
X478 n2283gat n1989gat n1918gat 343 NOR3_X1
X479 16 342 344 XNOR2_X1
X480 II1791 344 n3110gat NAND2_X1
X481 18 343 345 AND2_X1
X482 16 n1988gat 346 NAND2_X1
X483 18 343 347 XNOR2_X1
X484 II1795 347 n3109gat NAND2_X1
X485 19 345 348 XNOR2_X1
X486 II1800 348 n3108gat NAND2_X1
X487 n3088gat 82 349 NOR2_X1
X488 76 77 83 350 NOR3_X1
X489 n1787gat 163 351 XOR2_X1
X490 350 349 99 352 AOI21_X1
X491 351 352 n3105gat NAND2_X1
X492 n1631gat 170 353 XOR2_X1
X493 353 219 77 29 217 n3104gat OAI221_X1
X494 n1821gat n1825gat n1816gat NAND2_X1
X495 II414 II409 106 n1625gat NOR3_X1
X496 II414 10 106 n1626gat NOR3_X1
X497 103 156 n1836gat NAND2_X1
X498 103 106 156 n1781gat NAND3_X1
X499 n2510gat n2588gat n2502gat 354 AND3_X1
X500 n2658gat n2506gat 354 n2661gat NAND3_X1
X501 n2661gat 355 INV_X1
X502 n2446gat II3954 n3147gat NAND2_X1
X503 78 98 187 82 n827gat OAI22_X1
X504 n3100gat n2309gat 355 356 AOI21_X1
X505 n1879gat n2021gat 357 NAND2_X1
X506 n2095gat n2037gat 358 NAND2_X1
X507 356 358 357 n2099gat n3034gat AOI211_X1
X508 n3034gat 359 INV_X1
X509 n2265gat 340 360 XNOR2_X1
X510 n3034gat 360 n3036gat NAND2_X1
X511 174 n3034gat 361 NAND2_X1
X512 361 n3040gat INV_X1
X513 2 n1633gat n1787gat 159 362 AOI22_X1
X514 n1974gat 362 363 XOR2_X1
X515 174 n3034gat 363 n3053gat NAND3_X1
X516 183 n3034gat 364 NAND2_X1
X517 364 n3047gat INV_X1
X518 n2283gat 17 346 365 AOI21_X1
X519 n2643gat 365 366 XNOR2_X1
X520 n3047gat 366 n3054gat NAND2_X1
X521 n1339gat 97 116 157 367 NOR4_X1
X522 n1392gat n1461gat 264 368 NOR3_X1
X523 367 368 369 NOR2_X1
X524 n1393gat n1524gat 268 370 NOR3_X1
X525 n1879gat n2021gat n3097gat 371 NAND3_X1
X526 n1774gat n3098gat n3106gat 372 NOR3_X1
X527 372 n1816gat n1828gat 373 OAI21_X1
X528 373 371 n1825gat 374 AOI21_X1
X529 4 n1587gat n1858gat 375 NOR3_X1
X530 n1461gat n1858gat 376 NAND2_X1
X531 4 97 155 n1393gat 377 OAI211_X1
X532 n1677gat 376 377 378 AOI21_X1
X533 370 374 375 378 379 NOR4_X1
X534 379 369 n1507gat n3140gat OAI21_X1
X535 40 102 n1620gat NOR2_X1
X536 n3099gat 28 n1827gat NOR2_X1
X537 II368 n1691gat n1606gat NOR2_X1
X538 14 n3147gat 380 NAND2_X1
X539 n2472gat 380 n1816gat n1828gat 381 OAI211_X1
X540 II368 n1691gat 381 n1610gat NOR3_X1
X541 165 169 382 AND2_X1
X542 n1989gat n1988gat 19 178 383 OR4_X1
X543 382 383 n1793gat NOR2_X1
X544 n1631gat n1785gat n1787gat 384 NAND3_X1
X545 18 n1658gat 385 NOR2_X1
X546 n2283gat n1989gat n1918gat 385 386 NAND4_X1
X547 167 384 386 n1516gat NOR3_X1
X548 n1884gat n1633gat 383 384 n1565gat NOR4_X1
X549 II414 10 106 381 n1696gat NOR4_X1
X550 II726 II729 n1989gat 387 NAND3_X1
X551 n2283gat II687 388 XOR2_X1
X552 II692 n1918gat 389 XOR2_X1
X553 5 II692 II729 390 AND3_X1
X554 6 390 391 NAND2_X1
X555 387 388 389 391 n1989gat 181 392 OAI33_X1
X556 n1989gat 18 6 II729 393 AOI211_X1
X557 177 390 393 394 AOI21_X1
X558 6 II729 342 395 NAND3_X1
X559 395 178 6 396 OAI21_X1
X560 5 7 II729 397 NAND3_X1
X561 n1658gat 346 397 398 NOR3_X1
X562 3 17 n1658gat 394 399 NOR4_X1
X563 399 398 396 385 392 400 AOI221_X1
X564 235 400 401 NOR2_X1
X565 235 382 400 402 NOR3_X1
X566 402 n2021gat n1879gat n2017gat AOI21_X1
X567 356 402 403 OR2_X1
X568 403 n1774gat 21 n1879gat n2021gat n2009gat AOI221_X1
X569 n1787gat 167 404 NOR2_X1
X570 n1631gat n1785gat n1858gat 404 n1636gat AND4_X1
X571 21 n2168gat 403 n2163gat NOR3_X1
X572 n2039gat n1774gat n1315gat n2015gat NOR3_X1
X573 344 364 n3048gat NOR2_X1
X574 II414 II409 106 381 n1613gat NOR4_X1
X575 n2557gat 108 405 OR2_X1
X576 145 226 405 n1391gat NOR3_X1
X577 164 402 n1927gat NOR2_X1
X578 2 n1785gat 160 n1712gat NOR3_X1
X579 2 n1785gat 160 383 n1567gat NOR4_X1
X580 169 401 179 177 n1564gat AOI211_X1
X581 n1989gat n1988gat 19 181 406 OR4_X1
X582 171 406 n1915gat NOR2_X1
X583 164 406 n1800gat NOR2_X1
X584 21 167 384 n1593gat NOR3_X1
X585 359 II3394 n2189gat n3031gat AOI21_X1
X586 341 359 n3035gat NOR2_X1
X587 353 361 n3037gat NOR2_X1
X588 351 361 n3041gat NOR2_X1
X589 220 361 n3042gat NOR2_X1
X590 361 n1633gat n1884gat n3044gat AOI21_X1
X591 364 n1918gat n2283gat n3049gat AOI21_X1
X592 348 364 n3050gat NOR2_X1
X593 347 364 n3051gat NOR2_X1
X594 n2123gat n2117gat 380 n3052gat AND3_X1
X595 n1774gat n2514gat n1771gat 407 AND3_X1
X596 n2168gat n2176gat n2033gat n2110gat 408 NAND4_X1
X597 358 408 407 II3318 n3146gat AOI211_X1
X598 n1518gat 407 n3145gat NOR2_X1
X599 2 n1633gat 384 n1632gat NOR3_X1
X600 107 114 405 n3138gat NOR3_X1
X601 n3106gat n1771gat n1774gat n3107gat AOI21_X1
X602 379 369 n1507gat n3139gat OAI21_X1
X603 CK n672gat n2897gat dff
X604 CK II729 n3069gat dff
X605 CK II368 n3065gat dff
X606 CK n2551gat n3053gat dff
X607 CK n2506gat n2613gat dff
X608 CK n1834gat n1625gat dff
X609 CK n1767gat n1626gat dff
X610 CK n2084gat n1442gat dff
X611 CK n1787gat n2482gat dff
X612 CK n1785gat n2557gat dff
X613 CK n1633gat n2487gat dff
X614 CK n1884gat n2532gat dff
X615 CK n1631gat n2486gat dff
X616 CK II359 n3067gat dff
X617 CK n1989gat n2353gat dff
X618 CK n1918gat n2284gat dff
X619 CK n2283gat n2443gat dff
X620 CK n1658gat n2205gat dff
X621 CK n1988gat n2201gat dff
X622 CK n1389gat n1793gat dff
X623 CK n2021gat n1781gat dff
X624 CK n1393gat n1516gat dff
X625 CK n1495gat n1392gat dff
X626 CK n2090gat n1685gat dff
X627 CK II363 n3066gat dff
X628 CK n1332gat n1565gat dff
X629 CK n1739gat n1330gat dff
X630 CK n2178gat n1945gat dff
X631 CK n2189gat n2268gat dff
X632 CK n2134gat n2337gat dff
X633 CK II3394 n2388gat dff
X634 CK n2181gat n1836gat dff
X635 CK n1433gat n2983gat dff
X636 CK n1315gat n1431gat dff
X637 CK n1363gat n1314gat dff
X638 CK II406 n3073gat dff
X639 CK n1311gat n1361gat dff
X640 CK n1774gat n1696gat dff
X641 CK II3318 n2009gat dff
X642 CK n2591gat n1773gat dff
X643 CK n1507gat n1636gat dff
X644 CK n1677gat n1712gat dff
X645 CK n2309gat Vdd dff
X646 CK II3954 n2307gat dff
X647 CK n2446gat n2661gat dff
X648 CK n2095gat n827gat dff
X649 CK II461 n3068gat dff
X650 CK n2176gat n2093gat dff
X651 CK n2168gat n2174gat dff
X652 CK n1691gat n2163gat dff
X653 CK n2039gat n1518gat dff
X654 CK n2044gat n2015gat dff
X655 CK n2037gat n2042gat dff
X656 CK n2025gat n2017gat dff
X657 CK n2099gat n2023gat dff
X658 CK n2265gat n2493gat dff
X659 CK n2033gat n2035gat dff
X660 CK n2522gat n43gat dff
X661 CK n2110gat n2031gat dff
X662 CK n2124gat n2108gat dff
X663 CK n2121gat n2123gat dff
X664 CK n2117gat n2119gat dff
X665 CK n1974gat n2553gat dff
X666 CK n2643gat n2574gat dff
X667 CK n155gat n503gat dff
X668 CK n151gat n705gat dff
X669 CK n330gat n596gat dff
X670 CK n387gat n595gat dff
X671 CK n2472gat n1620gat dff
X672 CK n462gat n594gat dff
X673 CK n326gat n682gat dff
X674 CK n383gat n695gat dff
X675 CK n255gat n718gat dff
X676 CK n469gat n736gat dff
X677 CK n147gat n719gat dff
X678 CK n2458gat n2590gat dff
X679 CK n2514gat n2456gat dff
X680 CK n1771gat n1613gat dff
X681 CK n1336gat n1391gat dff
X682 CK n2319gat n2470gat dff
X683 CK n1747gat n1927gat dff
X684 CK n1674gat n1713gat dff
X685 CK n1806gat n1717gat dff
X686 CK n1339gat n1567gat dff
X687 CK n1455gat n1564gat dff
X688 CK n1524gat n1632gat dff
X689 CK n1461gat n1915gat dff
X690 CK n1595gat n1800gat dff
X691 CK n1587gat n1593gat dff
X692 CK n1821gat n1827gat dff
X693 CK n1825gat n1827gat dff
X694 CK II726 n3070gat dff
X695 CK n2029gat n1816gat dff
X696 CK n1828gat n2027gat dff
X697 CK II651 n3065gat dff
X698 CK II642 n3067gat dff
X699 CK II646 n3066gat dff
X700 CK II683 n3073gat dff
X701 CK II734 n3068gat dff
X702 CK n2476gat n55gat dff
X703 CK II851 n2914gat dff
X704 CK II842 n2928gat dff
X705 CK II687 n3072gat dff
X706 CK II846 n2927gat dff
X707 CK II930 n2896gat dff
X708 CK II921 n2922gat dff
X709 CK II925 n2897gat dff
X710 CK II1016 n2894gat dff
X711 CK II1007 n2921gat dff
X712 CK II1011 n2895gat dff
X713 CK n2468gat n933gat dff
X714 CK n499gat n3070gat dff
X715 CK n490gat n3069gat dff
X716 CK II692 n3071gat dff
X717 CK n621gat n3071gat dff
X718 CK n625gat n3072gat dff
X719 CK II1183 n3064gat dff
X720 CK II1174 n3055gat dff
X721 CK II1178 n3063gat dff
X722 CK II1209 n3062gat dff
X723 CK II1236 n3056gat dff
X724 CK n2526gat n504gat dff
X725 CK II1353 n2913gat dff
X726 CK II1344 n2920gat dff
X727 CK II456 n3069gat dff
X728 CK II1348 n2905gat dff
X729 CK II1416 n3057gat dff
X730 CK II1407 n3059gat dff
X731 CK II1411 n3058gat dff
X732 CK II1481 n2898gat dff
X733 CK II1472 n3060gat dff
X734 CK II1476 n3061gat dff
X735 CK n2464gat n567gat dff
X736 CK II2268 n3048gat dff
X737 CK II2242 n3049gat dff
X738 CK II453 n3070gat dff
X739 CK II2271 n3051gat dff
X740 CK II2238 n3047gat dff
X741 CK II2275 n3050gat dff
X742 CK n2536gat n3040gat dff
X743 CK II2389 n3044gat dff
X744 CK II2394 n3042gat dff
X745 CK n2550gat n3037gat dff
X746 CK n2429gat n3041gat dff
X747 CK n2101gat n1606gat dff
X748 CK n1879gat n3052gat dff
X749 CK II409 n3072gat dff
X750 CK n1762gat n1610gat dff
X751 CK n2154gat n1858gat dff
X752 CK II1800 n2918gat dff
X753 CK II1791 n2952gat dff
X754 CK II1795 n2919gat dff
X755 CK n1281gat n2910gat dff
X756 CK n1225gat n2907gat dff
X757 CK II1908 n2911gat dff
X758 CK II1899 n2912gat dff
X759 CK II1903 n2909gat dff
X760 CK II414 n3071gat dff
X761 CK n1196gat n2908gat dff
X762 CK II1961 n2971gat dff
X763 CK n666gat n2904gat dff
X764 CK II2049 n2891gat dff
X765 CK II2040 n2903gat dff
X766 CK II2044 n2915gat dff
X767 CK n560gat n2901gat dff
X768 CK n365gat n2890gat dff
X769 CK II2162 n2888gat dff
X770 CK II2153 n2887gat dff
X771 CK n2510gat n748gat dff
X772 CK II2157 n2886gat dff
X773 CK n2599gat n3010gat dff
X774 CK n2588gat n3016gat dff
X775 CK n2576gat n3054gat dff
X776 CK n2658gat n2579gat dff
X777 CK n2494gat n3036gat dff
X778 CK n2389gat n3034gat dff
X779 CK n2269gat n3031gat dff
X780 CK n2338gat n3035gat dff
X781 CK n2502gat n2646gat dff
V0 n2039gat n2040gat DC 0
V1 n2268gat n2046gat DC 0
V2 Vss n2048gat DC 0
V3 n1884gat n1899gat DC 0
V4 n3035gat n2057gat DC 0
V5 n1884gat n1898gat DC 0
V6 n1785gat n2060gat DC 0
V7 n1785gat n2061gat DC 0
V8 n2090gat n2091gat DC 0
V9 n2101gat n2102gat DC 0
V10 n2124gat n2125gat DC 0
V11 n2388gat n2127gat DC 0
V12 n2134gat n2135gat DC 0
V13 n1633gat n2138gat DC 0
V14 n1633gat n2139gat DC 0
V15 n1787gat n2142gat DC 0
V16 n1787gat n2143gat DC 0
V17 n3047gat n2147gat DC 0
V18 n1785gat n1891gat DC 0
V19 Vdd n1890gat DC 0
V20 n2154gat n2155gat DC 0
V21 n2168gat n2169gat DC 0
V22 n2178gat n2179gat DC 0
V23 n2181gat n2182gat DC 0
V24 Vss n2184gat DC 0
V25 n2189gat n2190gat DC 0
V26 n3034gat n2192gat DC 0
V27 n1884gat n1886gat DC 0
V28 n3031gat n2194gat DC 0
V29 n3040gat n2195gat DC 0
V30 n3051gat n2196gat DC 0
V31 n3050gat n2197gat DC 0
V32 n3049gat n2198gat DC 0
V33 Vdd n1885gat DC 0
V34 II2271 n2202gat DC 0
V35 II2271 n2203gat DC 0
V36 II2275 n2206gat DC 0
V37 II2275 n2207gat DC 0
V38 II2275 n2214gat DC 0
V39 n3052gat n1882gat DC 0
V40 n2205gat n2217gat DC 0
V41 n1879gat n1880gat DC 0
V42 II3394 n2251gat DC 0
V43 II3394 n2252gat DC 0
V44 II3318 n1871gat DC 0
V45 II3318 n1870gat DC 0
V46 n3106gat n1869gat DC 0
V47 II3394 n2261gat DC 0
V48 II3394 n2262gat DC 0
V49 n2265gat n2266gat DC 0
V50 II2162 n226gat DC 0
V51 n2269gat n2270gat DC 0
V52 II2153 n227gat DC 0
V53 II2268 n2285gat DC 0
V54 II2157 n228gat DC 0
V55 n2201gat n2290gat DC 0
V56 Vss n2328gat DC 0
V57 n3044gat n2330gat DC 0
V58 n2283gat n2332gat DC 0
V59 n2283gat n2333gat DC 0
V60 n2338gat n2339gat DC 0
V61 n1884gat n1954gat DC 0
V62 n2284gat n2341gat DC 0
V63 II2242 n2342gat DC 0
V64 II2242 n2343gat DC 0
V65 n1631gat n1850gat DC 0
V66 n1988gat n2346gat DC 0
V67 n1988gat n2347gat DC 0
V68 n1658gat n2351gat DC 0
V69 II2271 n2354gat DC 0
V70 II2242 n2355gat DC 0
V71 II2238 n2356gat DC 0
V72 n3042gat n2387gat DC 0
V73 n2389gat n2390gat DC 0
V74 n1631gat n1849gat DC 0
V75 n1918gat n2393gat DC 0
V76 n1918gat n2394gat DC 0
V77 n3048gat n2396gat DC 0
V78 n2353gat n2397gat DC 0
V79 II2268 n2398gat DC 0
V80 II2268 n2399gat DC 0
V81 n1884gat n1955gat DC 0
V82 n1989gat n2402gat DC 0
V83 n1989gat n2403gat DC 0
V84 n1658gat n2406gat DC 0
V85 n1658gat n2407gat DC 0
V86 II2275 n2414gat DC 0
V87 II2268 n2415gat DC 0
V88 II2271 n2416gat DC 0
V89 n2353gat n2417gat DC 0
V90 n2201gat n2418gat DC 0
V91 n2205gat n2419gat DC 0
V92 n3041gat n2436gat DC 0
V93 n1787gat n1845gat DC 0
V94 n2283gat n2439gat DC 0
V95 n2283gat n2440gat DC 0
V96 n3148gat n2448gat DC 0
V97 II3954 n2449gat DC 0
V98 II3954 n2450gat DC 0
V99 n1691gat n2454gat DC 0
V100 n3141gat II4122 DC 0
V101 n705gat II1152 DC 0
V102 n2284gat II2213 DC 0
V103 n2487gat n2488gat DC 0
V104 II2389 n2489gat DC 0
V105 n2576gat II2225 DC 0
V106 II2389 n2490gat DC 0
V107 n3036gat n2492gat DC 0
V108 n2494gat n2495gat DC 0
V109 n3047gat n2498gat DC 0
V110 n2443gat II2228 DC 0
V111 n2574gat II2232 DC 0
V112 n2574gat II2235 DC 0
V113 n3140gat II4222 DC 0
V114 n3139gat II4227 DC 0
V115 II1961 n2518gat DC 0
V116 n2205gat II2251 DC 0
V117 n2205gat II2254 DC 0
V118 n2353gat II2257 DC 0
V119 n3040gat n2539gat DC 0
V120 II2389 n2540gat DC 0
V121 n2482gat n2541gat DC 0
V122 n2429gat n2542gat DC 0
V123 n2429gat n2543gat DC 0
V124 n2389gat II4482 DC 0
V125 n2389gat II4485 DC 0
V126 n2269gat II4489 DC 0
V127 n2269gat II4492 DC 0
V128 n2429gat n2552gat DC 0
V129 n2482gat n2554gat DC 0
V130 n2486gat n2555gat DC 0
V131 n3037gat n2556gat DC 0
V132 n3053gat n2558gat DC 0
V133 n2443gat n2560gat DC 0
V134 II2238 n2561gat DC 0
V135 II2238 n2562gat DC 0
V136 n2338gat II4496 DC 0
V137 n2338gat II4499 DC 0
V138 n3116gat II4558 DC 0
V139 Vss II4566 DC 0
V140 n255gat n256gat DC 0
V141 Vss II4587 DC 0
V142 n2201gat II2260 DC 0
V143 II2242 n2573gat DC 0
V144 II2238 n2575gat DC 0
V145 n2443gat n2577gat DC 0
V146 n2284gat n2578gat DC 0
V147 n1828gat n1829gat DC 0
V148 n3106gat II4626 DC 0
V149 II3318 II4630 DC 0
V150 II3318 II4633 DC 0
V151 n2591gat n2592gat DC 0
V152 II3318 II4660 DC 0
V153 Vss II4678 DC 0
V154 n2201gat II2263 DC 0
V155 Vss II4687 DC 0
V156 n2338gat II4720 DC 0
V157 II2394 n2606gat DC 0
V158 n2532gat n2607gat DC 0
V159 II2389 n2608gat DC 0
V160 n2536gat n2609gat DC 0
V161 n2269gat II4723 DC 0
V162 n2487gat n2610gat DC 0
V163 n2557gat n2611gat DC 0
V164 II2394 n2612gat DC 0
V165 n2389gat II4726 DC 0
V166 n1806gat n1807gat DC 0
V167 n2557gat n2620gat DC 0
V168 II2394 n2621gat DC 0
V169 II2394 n2622gat DC 0
V170 n2532gat n2624gat DC 0
V171 n2536gat n2625gat DC 0
V172 n2536gat n2626gat DC 0
V173 n2486gat n2628gat DC 0
V174 n2550gat n2629gat DC 0
V175 n705gat II1155 DC 0
V176 n2550gat n2630gat DC 0
V177 n2553gat n2632gat DC 0
V178 n2551gat n2633gat DC 0
V179 n2551gat n2634gat DC 0
V180 n3054gat n2636gat DC 0
V181 n2574gat n2638gat DC 0
V182 n2576gat n2639gat DC 0
V183 II368 n263gat DC 0
V184 n2576gat n2640gat DC 0
V185 n2643gat n2644gat DC 0
V186 II3954 II4786 DC 0
V187 II359 n264gat DC 0
V188 Vss II4798 DC 0
V189 n2388gat II2316 DC 0
V190 II363 n265gat DC 0
V191 n2493gat II2319 DC 0
V192 n2337gat II2344 DC 0
V193 n3095gat n2667gat DC 0
V194 n3095gat n2668gat DC 0
V195 n3072gat n2670gat DC 0
V196 n3072gat n2671gat DC 0
V197 n3073gat n2673gat DC 0
V198 n3073gat n2674gat DC 0
V199 n2268gat n2677gat DC 0
V200 n2388gat n2678gat DC 0
V201 n3148gat n2679gat DC 0
V202 n3150gat n2680gat DC 0
V203 n2268gat n2681gat DC 0
V204 n2388gat n2682gat DC 0
V205 n3148gat n2683gat DC 0
V206 n3150gat n2684gat DC 0
V207 n3116gat n2685gat DC 0
V208 n2337gat n2686gat DC 0
V209 n2337gat n2688gat DC 0
V210 n3114gat n2689gat DC 0
V211 Vdd n2690gat DC 0
V212 n3146gat n2691gat DC 0
V213 n1442gat n2692gat DC 0
V214 n3114gat n2693gat DC 0
V215 Vdd n2694gat DC 0
V216 n1442gat n2696gat DC 0
V217 Vdd n2697gat DC 0
V218 n3113gat n2698gat DC 0
V219 n3145gat n2699gat DC 0
V220 n3151gat n2700gat DC 0
V221 Vdd n2701gat DC 0
V222 n3113gat n2702gat DC 0
V223 n3151gat n2704gat DC 0
V224 n3110gat n2705gat DC 0
V225 n3111gat n2706gat DC 0
V226 Vdd n2707gat DC 0
V227 n3110gat n2708gat DC 0
V228 n3111gat n2709gat DC 0
V229 II368 n270gat DC 0
V230 Vdd n2710gat DC 0
V231 n3075gat n2712gat DC 0
V232 n3088gat n2716gat DC 0
V233 n3088gat n2717gat DC 0
V234 n1633gat n1963gat DC 0
V235 n3074gat n2719gat DC 0
V236 II368 n271gat DC 0
V237 n1631gat n1783gat DC 0
V238 n3094gat n2721gat DC 0
V239 n3094gat n2722gat DC 0
V240 n3087gat n2724gat DC 0
V241 n3087gat n2725gat DC 0
V242 n3086gat n2727gat DC 0
V243 n3086gat n2728gat DC 0
V244 n3099gat n2729gat DC 0
V245 n3099gat n2730gat DC 0
V246 n3065gat n2732gat DC 0
V247 n3065gat n2733gat DC 0
V248 n3066gat n2735gat DC 0
V249 n3066gat n2736gat DC 0
V250 n3117gat n2737gat DC 0
V251 n3118gat n2738gat DC 0
V252 n3139gat n2739gat DC 0
V253 n3144gat n2740gat DC 0
V254 n3117gat n2741gat DC 0
V255 n3118gat n2742gat DC 0
V256 n3144gat n2744gat DC 0
V257 n3119gat n2745gat DC 0
V258 n3120gat n2746gat DC 0
V259 n3140gat n2747gat DC 0
V260 n3141gat n2748gat DC 0
V261 n3119gat n2749gat DC 0
V262 II734 n274gat DC 0
V263 n3120gat n2750gat DC 0
V264 n3121gat n2753gat DC 0
V265 n3122gat n2754gat DC 0
V266 n3141gat n2755gat DC 0
V267 n3121gat n2756gat DC 0
V268 n3122gat n2757gat DC 0
V269 n3123gat n2759gat DC 0
V270 II734 n275gat DC 0
V271 n3124gat n2760gat DC 0
V272 n3123gat n2761gat DC 0
V273 n3124gat n2762gat DC 0
V274 n3125gat n2763gat DC 0
V275 n3125gat n2764gat DC 0
V276 n3098gat n2765gat DC 0
V277 n3098gat n2766gat DC 0
V278 n3093gat n2767gat DC 0
V279 n3093gat n2768gat DC 0
V280 n1518gat n1777gat DC 0
V281 n3067gat n2776gat DC 0
V282 n3067gat n2777gat DC 0
V283 n1774gat n1775gat DC 0
V284 n3068gat n2779gat DC 0
V285 n3068gat n2780gat DC 0
V286 n3069gat n2782gat DC 0
V287 n3069gat n2783gat DC 0
V288 II646 n278gat DC 0
V289 n3070gat n2790gat DC 0
V290 n3070gat n2791gat DC 0
V291 n3071gat n2793gat DC 0
V292 n3071gat n2794gat DC 0
V293 n3108gat n2795gat DC 0
V294 n3109gat n2796gat DC 0
V295 n3143gat n2797gat DC 0
V296 n3108gat n2798gat DC 0
V297 n3109gat n2799gat DC 0
V298 II646 n279gat DC 0
V299 n3143gat n2800gat DC 0
V300 n3106gat n2801gat DC 0
V301 n3107gat n2802gat DC 0
V302 n3129gat n2803gat DC 0
V303 n3138gat n2804gat DC 0
V304 n3106gat n2805gat DC 0
V305 n3107gat n2806gat DC 0
V306 n3129gat n2807gat DC 0
V307 n3138gat n2808gat DC 0
V308 n3105gat n2809gat DC 0
V309 n3136gat n2810gat DC 0
V310 n3137gat n2811gat DC 0
V311 n3105gat n2812gat DC 0
V312 n3136gat n2813gat DC 0
V313 n3137gat n2814gat DC 0
V314 n3134gat n2815gat DC 0
V315 n3135gat n2816gat DC 0
V316 n3134gat n2817gat DC 0
V317 n3135gat n2818gat DC 0
V318 n3104gat n2819gat DC 0
V319 n1762gat n1763gat DC 0
V320 n3132gat n2820gat DC 0
V321 n3133gat n2821gat DC 0
V322 n3104gat n2822gat DC 0
V323 n3132gat n2823gat DC 0
V324 n3133gat n2824gat DC 0
V325 n3130gat n2825gat DC 0
V326 n3131gat n2826gat DC 0
V327 n3147gat n2827gat DC 0
V328 n3130gat n2828gat DC 0
V329 n3131gat n2829gat DC 0
V330 II651 n282gat DC 0
V331 n3147gat n2830gat DC 0
V332 n3090gat n2831gat DC 0
V333 n3090gat n2832gat DC 0
V334 n3077gat n2837gat DC 0
V335 n3076gat n2839gat DC 0
V336 II651 n283gat DC 0
V337 n3079gat n2841gat DC 0
V338 n3078gat n2843gat DC 0
V339 n3081gat n2845gat DC 0
V340 n3148gat n1754gat DC 0
V341 n3080gat n2847gat DC 0
V342 n3100gat n2850gat DC 0
V343 n3100gat n2851gat DC 0
V344 II646 n174gat DC 0
V345 n3082gat n2853gat DC 0
V346 n1747gat n1748gat DC 0
V347 n3083gat n2855gat DC 0
V348 n3083gat n2856gat DC 0
V349 n3097gat n2858gat DC 0
V350 n3107gat n1745gat DC 0
V351 n3085gat n2860gat DC 0
V352 n3085gat n2861gat DC 0
V353 n3084gat n2863gat DC 0
V354 n3084gat n2864gat DC 0
V355 n1658gat n1742gat DC 0
V356 n3089gat n2868gat DC 0
V357 n3089gat n2869gat DC 0
V358 n2268gat II2349 DC 0
V359 n1739gat n1740gat DC 0
V360 n718gat II1166 DC 0
V361 II642 n173gat DC 0
V362 n2557gat II2372 DC 0
V363 n2536gat II2376 DC 0
V364 n2487gat II2380 DC 0
V365 n3056gat n2892gat DC 0
V366 n2532gat II2385 DC 0
V367 n3061gat n2899gat DC 0
V368 n3057gat n2900gat DC 0
V369 II651 n172gat DC 0
V370 n3060gat n2916gat DC 0
V371 n3055gat n2917gat DC 0
V372 n3064gat n2923gat DC 0
V373 n3063gat n2924gat DC 0
V374 n3059gat n2925gat DC 0
V375 n3062gat n2926gat DC 0
V376 n3058gat n2929gat DC 0
V377 n2486gat II2403 DC 0
V378 n3135gat n2935gat DC 0
V379 n3131gat n2936gat DC 0
V380 n3134gat n2937gat DC 0
V381 n3132gat n2938gat DC 0
V382 n2553gat II2414 DC 0
V383 n3137gat n2941gat DC 0
V384 n2553gat II2417 DC 0
V385 n2482gat II2420 DC 0
V386 n2551gat II2425 DC 0
V387 n2429gat II2428 DC 0
V388 n718gat II1169 DC 0
V389 n2550gat II2433 DC 0
V390 n3136gat n2950gat DC 0
V391 n3129gat n2951gat DC 0
V392 n3138gat n1721gat DC 0
V393 n3130gat n2955gat DC 0
V394 n3133gat n2956gat DC 0
V395 n2353gat II1538 DC 0
V396 n2284gat II1550 DC 0
V397 n736gat II1201 DC 0
V398 n2487gat II1606 DC 0
V399 n2337gat n1708gat DC 0
V400 n3141gat n2980gat DC 0
V401 n2557gat II1617 DC 0
V402 n2486gat II1630 DC 0
V403 n736gat II1204 DC 0
V404 n1858gat n2989gat DC 0
V405 Vdd n2994gat DC 0
V406 n2532gat II1703 DC 0
V407 n2482gat II1708 DC 0
V408 Vdd n3000gat DC 0
V409 n1691gat n1699gat DC 0
V410 Vdd n3003gat DC 0
V411 n1974gat n1975gat DC 0
V412 n503gat II1227 DC 0
V413 n2443gat II1719 DC 0
V414 Vdd n3008gat DC 0
V415 n503gat II1230 DC 0
V416 n1518gat II2813 DC 0
V417 n1691gat n3020gat DC 0
V418 n1691gat n3021gat DC 0
V419 n1691gat n3022gat DC 0
V420 n1691gat n3023gat DC 0
V421 n1691gat n3024gat DC 0
V422 n1691gat n3025gat DC 0
V423 n1691gat n3026gat DC 0
V424 n1691gat n3027gat DC 0
V425 n1691gat n3028gat DC 0
V426 n3106gat n3029gat DC 0
V427 n3106gat n3030gat DC 0
V428 II3394 n3032gat DC 0
V429 n1884gat n3039gat DC 0
V430 n1633gat n3043gat DC 0
V431 n2283gat n3046gat DC 0
V432 Vdd n3112gat DC 0
V433 Vdd n3115gat DC 0
V434 n2337gat n3126gat DC 0
V435 n2268gat n3127gat DC 0
V436 n2388gat n3128gat DC 0
V437 II2157 n313gat DC 0
V438 n3141gat n3142gat DC 0
V439 n1442gat n3149gat DC 0
V440 II2157 n314gat DC 0
V441 Vdd n3152gat DC 0
V442 II2153 n317gat DC 0
V443 II2153 n318gat DC 0
V444 n1677gat n1678gat DC 0
V445 II2162 n321gat DC 0
V446 II2162 n322gat DC 0
V447 n326gat n327gat DC 0
V448 n1674gat n1675gat DC 0
V449 n330gat n331gat DC 0
V450 II363 n336gat DC 0
V451 II363 n337gat DC 0
V452 II461 n340gat DC 0
V453 II461 n341gat DC 0
V454 n621gat II1103 DC 0
V455 II734 n348gat DC 0
V456 II726 n349gat DC 0
V457 II729 n350gat DC 0
V458 II642 n165gat DC 0
V459 n625gat II1115 DC 0
V460 n365gat n366gat DC 0
V461 II642 n164gat DC 0
V462 II414 n1018gat DC 0
V463 II406 n1019gat DC 0
V464 II409 n1020gat DC 0
V465 n383gat n384gat DC 0
V466 n387gat n388gat DC 0
V467 II683 n1025gat DC 0
V468 II683 n1026gat DC 0
V469 II456 n393gat DC 0
V470 II456 n394gat DC 0
V471 II729 n397gat DC 0
V472 II729 n398gat DC 0
V473 n499gat II1067 DC 0
V474 II726 n401gat DC 0
V475 II726 n402gat DC 0
V476 II1800 n1034gat DC 0
V477 II1800 n1035gat DC 0
V478 II1903 n1044gat DC 0
V479 II1903 n1045gat DC 0
V480 n490gat II1079 DC 0
V481 II1016 n1055gat DC 0
V482 II1007 n1056gat DC 0
V483 II1011 n1057gat DC 0
V484 II359 n160gat DC 0
V485 II851 n1067gat DC 0
V486 II851 n1068gat DC 0
V487 II1795 n1071gat DC 0
V488 II1795 n1072gat DC 0
V489 n2590gat II3143 DC 0
V490 II1007 n1079gat DC 0
V491 II1007 n1080gat DC 0
V492 n1442gat n1603gat DC 0
V493 n1392gat II3168 DC 0
V494 II2049 n1084gat DC 0
V495 II2040 n1085gat DC 0
V496 n3106gat n1086gat DC 0
V497 n462gat n463gat DC 0
V498 n469gat n470gat DC 0
V499 II359 n159gat DC 0
V500 II461 n480gat DC 0
V501 II453 n481gat DC 0
V502 II456 n482gat DC 0
V503 n1595gat n1596gat DC 0
V504 n490gat n491gat DC 0
V505 n3147gat II3235 DC 0
V506 II3318 II3315 DC 0
V507 II1236 n498gat DC 0
V508 n490gat n500gat DC 0
V509 n1587gat n1588gat DC 0
V510 n1773gat II3339 DC 0
V511 n1314gat II3342 DC 0
V512 n596gat II1371 DC 0
V513 n155gat n156gat DC 0
V514 n596gat II1374 DC 0
V515 n594gat II1385 DC 0
V516 n594gat II1388 DC 0
V517 n3083gat II196 DC 0
V518 II1800 n1118gat DC 0
V519 II2040 n552gat DC 0
V520 II2040 n553gat DC 0
V521 n1884gat II3461 DC 0
V522 II1791 n1120gat DC 0
V523 II1791 n1121gat DC 0
V524 n560gat n561gat DC 0
V525 n365gat n566gat DC 0
V526 II1899 n1134gat DC 0
V527 II1899 n1135gat DC 0
V528 II1348 n579gat DC 0
V529 II1011 n1147gat DC 0
V530 II1348 n580gat DC 0
V531 II1481 n583gat DC 0
V532 II1481 n584gat DC 0
V533 n151gat n152gat DC 0
V534 II1011 n1148gat DC 0
V535 II2157 n1150gat DC 0
V536 n595gat II1399 DC 0
V537 II1416 n591gat DC 0
V538 II1407 n592gat DC 0
V539 II1411 n593gat DC 0
V540 n1524gat n1525gat DC 0
V541 n503gat n612gat DC 0
V542 II1236 n613gat DC 0
V543 II1236 n614gat DC 0
V544 n499gat n617gat DC 0
V545 n499gat n618gat DC 0
V546 n621gat n622gat DC 0
V547 n625gat n626gat DC 0
V548 n595gat II1402 DC 0
V549 n2283gat II3509 DC 0
V550 n3085gat II203 DC 0
V551 n1507gat n1508gat DC 0
V552 n2123gat II3587 DC 0
V553 n719gat II1138 DC 0
V554 II2049 n658gat DC 0
V555 II2049 n659gat DC 0
V556 n1495gat n1496gat DC 0
V557 n666gat n667gat DC 0
V558 n147gat n148gat DC 0
V559 n719gat II1141 DC 0
V560 n672gat n673gat DC 0
V561 II1353 n679gat DC 0
V562 II1353 n680gat DC 0
V563 II1472 n683gat DC 0
V564 II1472 n684gat DC 0
V565 n682gat II1450 DC 0
V566 n3084gat II210 DC 0
V567 II1481 n691gat DC 0
V568 II1472 n692gat DC 0
V569 II1476 n693gat DC 0
V570 n682gat n694gat DC 0
V571 n695gat n697gat DC 0
V572 II1476 n698gat DC 0
V573 II1476 n699gat DC 0
V574 II453 n702gat DC 0
V575 II453 n703gat DC 0
V576 II1174 n706gat DC 0
V577 II1174 n707gat DC 0
V578 n682gat II1453 DC 0
V579 II1800 n1189gat DC 0
V580 II1791 n1190gat DC 0
V581 II1183 n714gat DC 0
V582 II1174 n715gat DC 0
V583 II1178 n716gat DC 0
V584 n705gat n717gat DC 0
V585 II1795 n1191gat DC 0
V586 II409 n721gat DC 0
V587 II409 n722gat DC 0
V588 II414 n725gat DC 0
V589 II414 n726gat DC 0
V590 n1461gat n1462gat DC 0
V591 n621gat n733gat DC 0
V592 II1209 n734gat DC 0
V593 n625gat n735gat DC 0
V594 n1196gat n1197gat DC 0
V595 n1455gat n1456gat DC 0
V596 n695gat II1464 DC 0
V597 n695gat II1467 DC 0
V598 Vss II3923 DC 0
V599 II1908 n1206gat DC 0
V600 II1899 n1207gat DC 0
V601 II1903 n1208gat DC 0
V602 II3954 II3951 DC 0
V603 II2044 n776gat DC 0
V604 II2044 n777gat DC 0
V605 n3148gat II3957 DC 0
V606 II2049 n784gat DC 0
V607 II2040 n785gat DC 0
V608 II2044 n786gat DC 0
V609 n3085gat n1221gat DC 0
V610 n3084gat n1222gat DC 0
V611 n3083gat n1223gat DC 0
V612 n1225gat n1226gat DC 0
V613 II930 n1233gat DC 0
V614 II921 n1234gat DC 0
V615 II925 n1235gat DC 0
V616 II1353 n808gat DC 0
V617 II1344 n809gat DC 0
V618 II1348 n810gat DC 0
V619 II1344 n815gat DC 0
V620 II1344 n816gat DC 0
V621 n594gat n818gat DC 0
V622 II1407 n819gat DC 0
V623 II1407 n820gat DC 0
V624 n596gat n822gat DC 0
V625 II1416 n823gat DC 0
V626 II1416 n824gat DC 0
V627 n736gat n828gat DC 0
V628 II1209 n829gat DC 0
V629 II1209 n830gat DC 0
V630 n719gat n832gat DC 0
V631 II1183 n833gat DC 0
V632 II1183 n834gat DC 0
V633 n718gat n836gat DC 0
V634 II1178 n837gat DC 0
V635 II1178 n838gat DC 0
V636 II406 n841gat DC 0
V637 II406 n842gat DC 0
V638 II692 n845gat DC 0
V639 II692 n846gat DC 0
V640 II1908 n850gat DC 0
V641 n1393gat n1394gat DC 0
V642 II846 n860gat DC 0
V643 II846 n861gat DC 0
V644 II1016 n864gat DC 0
V645 II1016 n865gat DC 0
V646 II921 n1240gat DC 0
V647 II921 n1241gat DC 0
V648 n3141gat II4117 DC 0
V649 II2153 n873gat DC 0
V650 n560gat n875gat DC 0
V651 n595gat n881gat DC 0
V652 II1411 n882gat DC 0
V653 II1411 n883gat DC 0
V654 Vdd n1384gat DC 0
V655 n3116gat n1269gat DC 0
V656 n1281gat n1382gat DC 0
V657 n3034gat n2014gat DC 0
V658 II692 n911gat DC 0
V659 II683 n912gat DC 0
V660 II687 n913gat DC 0
V661 II687 n918gat DC 0
V662 II687 n919gat DC 0
V663 II1791 n922gat DC 0
V664 II1903 n923gat DC 0
V665 II1795 n924gat DC 0
V666 II1899 n927gat DC 0
V667 II1908 n930gat DC 0
V668 II1908 n931gat DC 0
V669 n1281gat n1282gat DC 0
V670 II851 n949gat DC 0
V671 II842 n950gat DC 0
V672 II846 n951gat DC 0
V673 n1442gat n1350gat DC 0
V674 II842 n956gat DC 0
V675 II842 n957gat DC 0
V676 n1339gat n1340gat DC 0
V677 II930 n1293gat DC 0
V678 II930 n1294gat DC 0
V679 II925 n1297gat DC 0
V680 II925 n1298gat DC 0
V681 II2162 n983gat DC 0
V682 n1311gat n1312gat DC 0
V683 II2044 n985gat DC 0
V684 n1315gat n1316gat DC 0
V685 n1225gat n1328gat DC 0

************************
* end of SPICE netlist *
************************

* Anti-Floating Pull-Downs (GMIN)
R_PD_0 96 0 100meg
R_PD_1 177 0 100meg
R_PD_2 187 0 100meg
R_PD_3 157 0 100meg
R_PD_4 275 0 100meg
R_PD_5 117 0 100meg
R_PD_6 n2907gat 0 100meg
R_PD_7 38 0 100meg
R_PD_8 n3035gat 0 100meg
R_PD_9 II846 0 100meg
R_PD_10 398 0 100meg
R_PD_11 225 0 100meg
R_PD_12 259 0 100meg
R_PD_13 II683 0 100meg
R_PD_14 330 0 100meg
R_PD_15 109 0 100meg
R_PD_16 n1747gat 0 100meg
R_PD_17 363 0 100meg
R_PD_18 n3095gat 0 100meg
R_PD_19 n2918gat 0 100meg
R_PD_20 72 0 100meg
R_PD_21 n2486gat 0 100meg
R_PD_22 313 0 100meg
R_PD_23 II1476 0 100meg
R_PD_24 n3133gat 0 100meg
R_PD_25 161 0 100meg
R_PD_26 304 0 100meg
R_PD_27 76 0 100meg
R_PD_28 211 0 100meg
R_PD_29 n1442gat 0 100meg
R_PD_30 200 0 100meg
R_PD_31 229 0 100meg
R_PD_32 239 0 100meg
R_PD_33 n695gat 0 100meg
R_PD_34 n3120gat 0 100meg
R_PD_35 383 0 100meg
R_PD_36 n2044gat 0 100meg
R_PD_37 II1791 0 100meg
R_PD_38 354 0 100meg
R_PD_39 n1564gat 0 100meg
R_PD_40 n1771gat 0 100meg
R_PD_41 102 0 100meg
R_PD_42 52 0 100meg
R_PD_43 127 0 100meg
R_PD_44 II456 0 100meg
R_PD_45 321 0 100meg
R_PD_46 43 0 100meg
R_PD_47 242 0 100meg
R_PD_48 135 0 100meg
R_PD_49 n567gat 0 100meg
R_PD_50 222 0 100meg
R_PD_51 n3058gat 0 100meg
R_PD_52 61 0 100meg
R_PD_53 II409 0 100meg
R_PD_54 324 0 100meg
R_PD_55 215 0 100meg
R_PD_56 n3141gat 0 100meg
R_PD_57 n2920gat 0 100meg
R_PD_58 n3048gat 0 100meg
R_PD_59 n3089gat 0 100meg
R_PD_60 n2268gat 0 100meg
R_PD_61 II2157 0 100meg
R_PD_62 48 0 100meg
R_PD_63 n2093gat 0 100meg
R_PD_64 n3116gat 0 100meg
R_PD_65 228 0 100meg
R_PD_66 n3047gat 0 100meg
R_PD_67 n1626gat 0 100meg
R_PD_68 n2389gat 0 100meg
R_PD_69 n2579gat 0 100meg
R_PD_70 350 0 100meg
R_PD_71 n1774gat 0 100meg
R_PD_72 106 0 100meg
R_PD_73 58 0 100meg
R_PD_74 230 0 100meg
R_PD_75 n2470gat 0 100meg
R_PD_76 260 0 100meg
R_PD_77 10 0 100meg
R_PD_78 n736gat 0 100meg
R_PD_79 n151gat 0 100meg
R_PD_80 n1593gat 0 100meg
R_PD_81 n2908gat 0 100meg
R_PD_82 n2927gat 0 100meg
R_PD_83 n3072gat 0 100meg
R_PD_84 56 0 100meg
R_PD_85 n2029gat 0 100meg
R_PD_86 68 0 100meg
R_PD_87 208 0 100meg
R_PD_88 n2337gat 0 100meg
R_PD_89 37 0 100meg
R_PD_90 n596gat 0 100meg
R_PD_91 134 0 100meg
R_PD_92 n2613gat 0 100meg
R_PD_93 n3118gat 0 100meg
R_PD_94 3 0 100meg
R_PD_95 n625gat 0 100meg
R_PD_96 406 0 100meg
R_PD_97 n3052gat 0 100meg
R_PD_98 II729 0 100meg
R_PD_99 20 0 100meg
R_PD_100 276 0 100meg
R_PD_101 II3394 0 100meg
R_PD_102 n1767gat 0 100meg
R_PD_103 404 0 100meg
R_PD_104 307 0 100meg
R_PD_105 396 0 100meg
R_PD_106 n2443gat 0 100meg
R_PD_107 n2090gat 0 100meg
R_PD_108 n3138gat 0 100meg
R_PD_109 n3068gat 0 100meg
R_PD_110 n2309gat 0 100meg
R_PD_111 355 0 100meg
R_PD_112 214 0 100meg
R_PD_113 II2238 0 100meg
R_PD_114 n3104gat 0 100meg
R_PD_115 n560gat 0 100meg
R_PD_116 II651 0 100meg
R_PD_117 n1196gat 0 100meg
R_PD_118 n2205gat 0 100meg
R_PD_119 II646 0 100meg
R_PD_120 165 0 100meg
R_PD_121 271 0 100meg
R_PD_122 n3135gat 0 100meg
R_PD_123 180 0 100meg
R_PD_124 n1339gat 0 100meg
R_PD_125 142 0 100meg
R_PD_126 151 0 100meg
R_PD_127 364 0 100meg
R_PD_128 n3137gat 0 100meg
R_PD_129 302 0 100meg
R_PD_130 II1209 0 100meg
R_PD_131 n2099gat 0 100meg
R_PD_132 17 0 100meg
R_PD_133 n2446gat 0 100meg
R_PD_134 166 0 100meg
R_PD_135 36 0 100meg
R_PD_136 343 0 100meg
R_PD_137 138 0 100meg
R_PD_138 II2271 0 100meg
R_PD_139 202 0 100meg
R_PD_140 n1974gat 0 100meg
R_PD_141 322 0 100meg
R_PD_142 257 0 100meg
R_PD_143 261 0 100meg
R_PD_144 236 0 100meg
R_PD_145 325 0 100meg
R_PD_146 n1879gat 0 100meg
R_PD_147 n2110gat 0 100meg
R_PD_148 53 0 100meg
R_PD_149 59 0 100meg
R_PD_150 n504gat 0 100meg
R_PD_151 n2886gat 0 100meg
R_PD_152 113 0 100meg
R_PD_153 n2522gat 0 100meg
R_PD_154 n1806gat 0 100meg
R_PD_155 310 0 100meg
R_PD_156 128 0 100meg
R_PD_157 369 0 100meg
R_PD_158 287 0 100meg
R_PD_159 n1587gat 0 100meg
R_PD_160 n2909gat 0 100meg
R_PD_161 318 0 100meg
R_PD_162 II406 0 100meg
R_PD_163 n3134gat 0 100meg
R_PD_164 125 0 100meg
R_PD_165 365 0 100meg
R_PD_166 II1353 0 100meg
R_PD_167 n2472gat 0 100meg
R_PD_168 255 0 100meg
R_PD_169 92 0 100meg
R_PD_170 22 0 100meg
R_PD_171 n3061gat 0 100meg
R_PD_172 n1696gat 0 100meg
R_PD_173 n2887gat 0 100meg
R_PD_174 44 0 100meg
R_PD_175 71 0 100meg
R_PD_176 n155gat 0 100meg
R_PD_177 II414 0 100meg
R_PD_178 256 0 100meg
R_PD_179 262 0 100meg
R_PD_180 41 0 100meg
R_PD_181 209 0 100meg
R_PD_182 n1461gat 0 100meg
R_PD_183 130 0 100meg
R_PD_184 152 0 100meg
R_PD_185 n1658gat 0 100meg
R_PD_186 n2599gat 0 100meg
R_PD_187 104 0 100meg
R_PD_188 n3140gat 0 100meg
R_PD_189 n1431gat 0 100meg
R_PD_190 111 0 100meg
R_PD_191 237 0 100meg
R_PD_192 277 0 100meg
R_PD_193 243 0 100meg
R_PD_194 n1834gat 0 100meg
R_PD_195 31 0 100meg
R_PD_196 II1795 0 100meg
R_PD_197 n2121gat 0 100meg
R_PD_198 n3146gat 0 100meg
R_PD_199 n2025gat 0 100meg
R_PD_200 n3139gat 0 100meg
R_PD_201 Q 0 100meg
R_PD_202 n748gat 0 100meg
R_PD_203 n1281gat 0 100meg
R_PD_204 159 0 100meg
R_PD_205 n2553gat 0 100meg
R_PD_206 389 0 100meg
R_PD_207 II1016 0 100meg
R_PD_208 27 0 100meg
R_PD_209 II1344 0 100meg
R_PD_210 78 0 100meg
R_PD_211 n2536gat 0 100meg
R_PD_212 n1455gat 0 100meg
R_PD_213 n3129gat 0 100meg
R_PD_214 323 0 100meg
R_PD_215 n2338gat 0 100meg
R_PD_216 n2035gat 0 100meg
R_PD_217 366 0 100meg
R_PD_218 13 0 100meg
R_PD_219 381 0 100meg
R_PD_220 n2526gat 0 100meg
R_PD_221 n2265gat 0 100meg
R_PD_222 346 0 100meg
R_PD_223 178 0 100meg
R_PD_224 n365gat 0 100meg
R_PD_225 n1330gat 0 100meg
R_PD_226 162 0 100meg
R_PD_227 n2510gat 0 100meg
R_PD_228 n2502gat 0 100meg
R_PD_229 405 0 100meg
R_PD_230 II2040 0 100meg
R_PD_231 300 0 100meg
R_PD_232 386 0 100meg
R_PD_233 n2319gat 0 100meg
R_PD_234 253 0 100meg
R_PD_235 n469gat 0 100meg
R_PD_236 21 0 100meg
R_PD_237 269 0 100meg
R_PD_238 382 0 100meg
R_PD_239 342 0 100meg
R_PD_240 169 0 100meg
R_PD_241 II842 0 100meg
R_PD_242 331 0 100meg
R_PD_243 n1988gat 0 100meg
R_PD_244 n3110gat 0 100meg
R_PD_245 357 0 100meg
R_PD_246 65 0 100meg
R_PD_247 327 0 100meg
R_PD_248 87 0 100meg
R_PD_249 n2896gat 0 100meg
R_PD_250 n2576gat 0 100meg
R_PD_251 280 0 100meg
R_PD_252 344 0 100meg
R_PD_253 n1567gat 0 100meg
R_PD_254 136 0 100meg
R_PD_255 n2915gat 0 100meg
R_PD_256 232 0 100meg
R_PD_257 II453 0 100meg
R_PD_258 244 0 100meg
R_PD_259 66 0 100meg
R_PD_260 n2174gat 0 100meg
R_PD_261 51 0 100meg
R_PD_262 349 0 100meg
R_PD_263 n3016gat 0 100meg
R_PD_264 26 0 100meg
R_PD_265 279 0 100meg
R_PD_266 n3109gat 0 100meg
R_PD_267 339 0 100meg
R_PD_268 n2039gat 0 100meg
R_PD_269 407 0 100meg
R_PD_270 107 0 100meg
R_PD_271 II1903 0 100meg
R_PD_272 n3066gat 0 100meg
R_PD_273 n503gat 0 100meg
R_PD_274 1 0 100meg
R_PD_275 100 0 100meg
R_PD_276 301 0 100meg
R_PD_277 n1631gat 0 100meg
R_PD_278 235 0 100meg
R_PD_279 n1393gat 0 100meg
R_PD_280 116 0 100meg
R_PD_281 n2905gat 0 100meg
R_PD_282 267 0 100meg
R_PD_283 372 0 100meg
R_PD_284 n1781gat 0 100meg
R_PD_285 n3082gat 0 100meg
R_PD_286 II2049 0 100meg
R_PD_287 n1712gat 0 100meg
R_PD_288 n2031gat 0 100meg
R_PD_289 n3113gat 0 100meg
R_PD_290 293 0 100meg
R_PD_291 144 0 100meg
R_PD_292 89 0 100meg
R_PD_293 n1389gat 0 100meg
R_PD_294 153 0 100meg
R_PD_295 332 0 100meg
R_PD_296 121 0 100meg
R_PD_297 149 0 100meg
R_PD_298 97 0 100meg
R_PD_299 n2307gat 0 100meg
R_PD_300 15 0 100meg
R_PD_301 314 0 100meg
R_PD_302 238 0 100meg
R_PD_303 n3122gat 0 100meg
R_PD_304 4 0 100meg
R_PD_305 n2154gat 0 100meg
R_PD_306 n330gat 0 100meg
R_PD_307 n1836gat 0 100meg
R_PD_308 360 0 100meg
R_PD_309 II2394 0 100meg
R_PD_310 375 0 100meg
R_PD_311 n3086gat 0 100meg
R_PD_312 II363 0 100meg
R_PD_313 201 0 100meg
R_PD_314 7 0 100meg
R_PD_315 231 0 100meg
R_PD_316 246 0 100meg
R_PD_317 207 0 100meg
R_PD_318 150 0 100meg
R_PD_319 370 0 100meg
R_PD_320 n3114gat 0 100meg
R_PD_321 337 0 100meg
R_PD_322 408 0 100meg
R_PD_323 n2163gat 0 100meg
R_PD_324 n3056gat 0 100meg
R_PD_325 n2921gat 0 100meg
R_PD_326 254 0 100meg
R_PD_327 306 0 100meg
R_PD_328 316 0 100meg
R_PD_329 263 0 100meg
R_PD_330 192 0 100meg
R_PD_331 309 0 100meg
R_PD_332 395 0 100meg
R_PD_333 399 0 100meg
R_PD_334 n1225gat 0 100meg
R_PD_335 n2588gat 0 100meg
R_PD_336 298 0 100meg
R_PD_337 34 0 100meg
R_PD_338 219 0 100meg
R_PD_339 393 0 100meg
R_PD_340 367 0 100meg
R_PD_341 241 0 100meg
R_PD_342 290 0 100meg
R_PD_343 n3075gat 0 100meg
R_PD_344 n2591gat 0 100meg
R_PD_345 299 0 100meg
R_PD_346 245 0 100meg
R_PD_347 172 0 100meg
R_PD_348 n2388gat 0 100meg
R_PD_349 n3031gat 0 100meg
R_PD_350 n2023gat 0 100meg
R_PD_351 223 0 100meg
R_PD_352 190 0 100meg
R_PD_353 n1595gat 0 100meg
R_PD_354 n2891gat 0 100meg
R_PD_355 252 0 100meg
R_PD_356 n1713gat 0 100meg
R_PD_357 88 0 100meg
R_PD_358 n2506gat 0 100meg
R_PD_359 n2353gat 0 100meg
R_PD_360 93 0 100meg
R_PD_361 335 0 100meg
R_PD_362 n3125gat 0 100meg
R_PD_363 n3034gat 0 100meg
R_PD_364 n3059gat 0 100meg
R_PD_365 n3042gat 0 100meg
R_PD_366 n3037gat 0 100meg
R_PD_367 249 0 100meg
R_PD_368 n1785gat 0 100meg
R_PD_369 251 0 100meg
R_PD_370 32 0 100meg
R_PD_371 371 0 100meg
R_PD_372 n2168gat 0 100meg
R_PD_373 182 0 100meg
R_PD_374 n2015gat 0 100meg
R_PD_375 14 0 100meg
R_PD_376 n3076gat 0 100meg
R_PD_377 175 0 100meg
R_PD_378 n1625gat 0 100meg
R_PD_379 n2898gat 0 100meg
R_PD_380 84 0 100meg
R_PD_381 n2283gat 0 100meg
R_PD_382 II1800 0 100meg
R_PD_383 n3151gat 0 100meg
R_PD_384 n3100gat 0 100meg
R_PD_385 274 0 100meg
R_PD_386 n2117gat 0 100meg
R_PD_387 185 0 100meg
R_PD_388 n1827gat 0 100meg
R_PD_389 n2134gat 0 100meg
R_PD_390 191 0 100meg
R_PD_391 296 0 100meg
R_PD_392 n1633gat 0 100meg
R_PD_393 400 0 100meg
R_PD_394 n2661gat 0 100meg
R_PD_395 n490gat 0 100meg
R_PD_396 II3318 0 100meg
R_PD_397 176 0 100meg
R_PD_398 n3069gat 0 100meg
R_PD_399 n3083gat 0 100meg
R_PD_400 n2914gat 0 100meg
R_PD_401 n1516gat 0 100meg
R_PD_402 295 0 100meg
R_PD_403 n2888gat 0 100meg
R_PD_404 n2124gat 0 100meg
R_PD_405 194 0 100meg
R_PD_406 II461 0 100meg
R_PD_407 n3087gat 0 100meg
R_PD_408 233 0 100meg
R_PD_409 358 0 100meg
R_PD_410 n1361gat 0 100meg
R_PD_411 317 0 100meg
R_PD_412 234 0 100meg
R_PD_413 n3121gat 0 100meg
R_PD_414 II1411 0 100meg
R_PD_415 148 0 100meg
R_PD_416 390 0 100meg
R_PD_417 n3078gat 0 100meg
R_PD_418 n1927gat 0 100meg
R_PD_419 II2242 0 100meg
R_PD_420 n3070gat 0 100meg
R_PD_421 60 0 100meg
R_PD_422 n3124gat 0 100meg
R_PD_423 266 0 100meg
R_PD_424 n3073gat 0 100meg
R_PD_425 55 0 100meg
R_PD_426 n2176gat 0 100meg
R_PD_427 II642 0 100meg
R_PD_428 39 0 100meg
R_PD_429 18 0 100meg
R_PD_430 179 0 100meg
R_PD_431 126 0 100meg
R_PD_432 158 0 100meg
R_PD_433 401 0 100meg
R_PD_434 n1800gat 0 100meg
R_PD_435 D 0 100meg
R_PD_436 137 0 100meg
R_PD_437 23 0 100meg
R_PD_438 30 0 100meg
R_PD_439 II2268 0 100meg
R_PD_440 221 0 100meg
R_PD_441 167 0 100meg
R_PD_442 n3081gat 0 100meg
R_PD_443 n2910gat 0 100meg
R_PD_444 132 0 100meg
R_PD_445 n1762gat 0 100meg
R_PD_446 29 0 100meg
R_PD_447 351 0 100meg
R_PD_448 90 0 100meg
R_PD_449 294 0 100meg
R_PD_450 n3071gat 0 100meg
R_PD_451 347 0 100meg
R_PD_452 6 0 100meg
R_PD_453 n2027gat 0 100meg
R_PD_454 216 0 100meg
R_PD_455 146 0 100meg
R_PD_456 402 0 100meg
R_PD_457 n3107gat 0 100meg
R_PD_458 n1773gat 0 100meg
R_PD_459 64 0 100meg
R_PD_460 n2476gat 0 100meg
R_PD_461 II2389 0 100meg
R_PD_462 n55gat 0 100meg
R_PD_463 n1632gat 0 100meg
R_PD_464 n2895gat 0 100meg
R_PD_465 73 0 100meg
R_PD_466 164 0 100meg
R_PD_467 II1348 0 100meg
R_PD_468 384 0 100meg
R_PD_469 n383gat 0 100meg
R_PD_470 374 0 100meg
R_PD_471 n3092gat 0 100meg
R_PD_472 n1915gat 0 100meg
R_PD_473 156 0 100meg
R_PD_474 264 0 100meg
R_PD_475 131 0 100meg
R_PD_476 n3090gat 0 100meg
R_PD_477 n1636gat 0 100meg
R_PD_478 n2456gat 0 100meg
R_PD_479 115 0 100meg
R_PD_480 160 0 100meg
R_PD_481 397 0 100meg
R_PD_482 n3079gat 0 100meg
R_PD_483 186 0 100meg
R_PD_484 n666gat 0 100meg
R_PD_485 147 0 100meg
R_PD_486 n3077gat 0 100meg
R_PD_487 74 0 100meg
R_PD_488 n2646gat 0 100meg
R_PD_489 46 0 100meg
R_PD_490 247 0 100meg
R_PD_491 n3099gat 0 100meg
R_PD_492 403 0 100meg
R_PD_493 198 0 100meg
R_PD_494 n3062gat 0 100meg
R_PD_495 n1677gat 0 100meg
R_PD_496 n2551gat 0 100meg
R_PD_497 II930 0 100meg
R_PD_498 170 0 100meg
R_PD_499 173 0 100meg
R_PD_500 288 0 100meg
R_PD_501 124 0 100meg
R_PD_502 II1416 0 100meg
R_PD_503 n1518gat 0 100meg
R_PD_504 240 0 100meg
R_PD_505 II1178 0 100meg
R_PD_506 8 0 100meg
R_PD_507 227 0 100meg
R_PD_508 n1945gat 0 100meg
R_PD_509 99 0 100meg
R_PD_510 265 0 100meg
R_PD_511 n3123gat 0 100meg
R_PD_512 n2181gat 0 100meg
R_PD_513 n2429gat 0 100meg
R_PD_514 199 0 100meg
R_PD_515 II359 0 100meg
R_PD_516 54 0 100meg
R_PD_517 108 0 100meg
R_PD_518 n594gat 0 100meg
R_PD_519 n2178gat 0 100meg
R_PD_520 217 0 100meg
R_PD_521 n2643gat 0 100meg
R_PD_522 n933gat 0 100meg
R_PD_523 n1363gat 0 100meg
R_PD_524 n1606gat 0 100meg
R_PD_525 112 0 100meg
R_PD_526 283 0 100meg
R_PD_527 n705gat 0 100meg
R_PD_528 86 0 100meg
R_PD_529 n1392gat 0 100meg
R_PD_530 n1821gat 0 100meg
R_PD_531 n3036gat 0 100meg
R_PD_532 28 0 100meg
R_PD_533 n2532gat 0 100meg
R_PD_534 120 0 100meg
R_PD_535 n3044gat 0 100meg
R_PD_536 n3067gat 0 100meg
R_PD_537 226 0 100meg
R_PD_538 118 0 100meg
R_PD_539 n1311gat 0 100meg
R_PD_540 212 0 100meg
R_PD_541 n3057gat 0 100meg
R_PD_542 303 0 100meg
R_PD_543 33 0 100meg
R_PD_544 338 0 100meg
R_PD_545 n3041gat 0 100meg
R_PD_546 n326gat 0 100meg
R_PD_547 II2153 0 100meg
R_PD_548 98 0 100meg
R_PD_549 391 0 100meg
R_PD_550 297 0 100meg
R_PD_551 n2913gat 0 100meg
R_PD_552 n147gat 0 100meg
R_PD_553 392 0 100meg
R_PD_554 94 0 100meg
R_PD_555 171 0 100meg
R_PD_556 155 0 100meg
R_PD_557 n1717gat 0 100meg
R_PD_558 348 0 100meg
R_PD_559 379 0 100meg
R_PD_560 n2903gat 0 100meg
R_PD_561 273 0 100meg
R_PD_562 189 0 100meg
R_PD_563 n1884gat 0 100meg
R_PD_564 376 0 100meg
R_PD_565 n1739gat 0 100meg
R_PD_566 n3148gat 0 100meg
R_PD_567 139 0 100meg
R_PD_568 n3106gat 0 100meg
R_PD_569 80 0 100meg
R_PD_570 286 0 100meg
R_PD_571 n2922gat 0 100meg
R_PD_572 n2557gat 0 100meg
R_PD_573 45 0 100meg
R_PD_574 II925 0 100meg
R_PD_575 II2162 0 100meg
R_PD_576 292 0 100meg
R_PD_577 n3119gat 0 100meg
R_PD_578 n2514gat 0 100meg
R_PD_579 248 0 100meg
R_PD_580 213 0 100meg
R_PD_581 n255gat 0 100meg
R_PD_582 49 0 100meg
R_PD_583 62 0 100meg
R_PD_584 n2550gat 0 100meg
R_PD_585 122 0 100meg
R_PD_586 II1908 0 100meg
R_PD_587 n2901gat 0 100meg
R_PD_588 n3144gat 0 100meg
R_PD_589 n3147gat 0 100meg
R_PD_590 II851 0 100meg
R_PD_591 205 0 100meg
R_PD_592 II3954 0 100meg
R_PD_593 220 0 100meg
R_PD_594 n2042gat 0 100meg
R_PD_595 n1507gat 0 100meg
R_PD_596 319 0 100meg
R_PD_597 203 0 100meg
R_PD_598 143 0 100meg
R_PD_599 67 0 100meg
R_PD_600 n3060gat 0 100meg
R_PD_601 n2919gat 0 100meg
R_PD_602 278 0 100meg
R_PD_603 312 0 100meg
R_PD_604 272 0 100meg
R_PD_605 n2482gat 0 100meg
R_PD_606 281 0 100meg
R_PD_607 n1433gat 0 100meg
R_PD_608 291 0 100meg
R_PD_609 340 0 100meg
R_PD_610 328 0 100meg
R_PD_611 n2021gat 0 100meg
R_PD_612 n3040gat 0 100meg
R_PD_613 5 0 100meg
R_PD_614 II2275 0 100meg
R_PD_615 101 0 100meg
R_PD_616 II1481 0 100meg
R_PD_617 174 0 100meg
R_PD_618 II1174 0 100meg
R_PD_619 258 0 100meg
R_PD_620 n1610gat 0 100meg
R_PD_621 n1565gat 0 100meg
R_PD_622 n2493gat 0 100meg
R_PD_623 n3108gat 0 100meg
R_PD_624 n595gat 0 100meg
R_PD_625 n2037gat 0 100meg
R_PD_626 n2269gat 0 100meg
R_PD_627 69 0 100meg
R_PD_628 n1336gat 0 100meg
R_PD_629 50 0 100meg
R_PD_630 184 0 100meg
R_PD_631 n1691gat 0 100meg
R_PD_632 110 0 100meg
R_PD_633 n2009gat 0 100meg
R_PD_634 119 0 100meg
R_PD_635 II1472 0 100meg
R_PD_636 n3094gat 0 100meg
R_PD_637 181 0 100meg
R_PD_638 n462gat 0 100meg
R_PD_639 24 0 100meg
R_PD_640 57 0 100meg
R_PD_641 9 0 100meg
R_PD_642 12 0 100meg
R_PD_643 n2017gat 0 100meg
R_PD_644 377 0 100meg
R_PD_645 140 0 100meg
R_PD_646 n2101gat 0 100meg
R_PD_647 n2189gat 0 100meg
R_PD_648 n3055gat 0 100meg
R_PD_649 n2464gat 0 100meg
R_PD_650 n3084gat 0 100meg
R_PD_651 n3054gat 0 100meg
R_PD_652 n3051gat 0 100meg
R_PD_653 II1007 0 100meg
R_PD_654 103 0 100meg
R_PD_655 40 0 100meg
R_PD_656 n3091gat 0 100meg
R_PD_657 n1314gat 0 100meg
R_PD_658 n2494gat 0 100meg
R_PD_659 n827gat 0 100meg
R_PD_660 n3145gat 0 100meg
R_PD_661 195 0 100meg
R_PD_662 n3136gat 0 100meg
R_PD_663 n1332gat 0 100meg
R_PD_664 n2574gat 0 100meg
R_PD_665 II692 0 100meg
R_PD_666 285 0 100meg
R_PD_667 83 0 100meg
R_PD_668 n3050gat 0 100meg
R_PD_669 n1989gat 0 100meg
R_PD_670 n3117gat 0 100meg
R_PD_671 n2590gat 0 100meg
R_PD_672 210 0 100meg
R_PD_673 2 0 100meg
R_PD_674 n1825gat 0 100meg
R_PD_675 308 0 100meg
R_PD_676 n2904gat 0 100meg
R_PD_677 II1236 0 100meg
R_PD_678 341 0 100meg
R_PD_679 75 0 100meg
R_PD_680 394 0 100meg
R_PD_681 n2468gat 0 100meg
R_PD_682 n3053gat 0 100meg
R_PD_683 n3063gat 0 100meg
R_PD_684 141 0 100meg
R_PD_685 356 0 100meg
R_PD_686 82 0 100meg
R_PD_687 105 0 100meg
R_PD_688 n2890gat 0 100meg
R_PD_689 168 0 100meg
R_PD_690 II734 0 100meg
R_PD_691 n2912gat 0 100meg
R_PD_692 n2487gat 0 100meg
R_PD_693 362 0 100meg
R_PD_694 n387gat 0 100meg
R_PD_695 n499gat 0 100meg
R_PD_696 85 0 100meg
R_PD_697 311 0 100meg
R_PD_698 79 0 100meg
R_PD_699 378 0 100meg
R_PD_700 n718gat 0 100meg
R_PD_701 n1315gat 0 100meg
R_PD_702 II368 0 100meg
R_PD_703 154 0 100meg
R_PD_704 n1391gat 0 100meg
R_PD_705 n3065gat 0 100meg
R_PD_706 n2658gat 0 100meg
R_PD_707 204 0 100meg
R_PD_708 n3010gat 0 100meg
R_PD_709 n1620gat 0 100meg
R_PD_710 224 0 100meg
R_PD_711 16 0 100meg
R_PD_712 II1961 0 100meg
R_PD_713 70 0 100meg
R_PD_714 163 0 100meg
R_PD_715 193 0 100meg
R_PD_716 77 0 100meg
R_PD_717 183 0 100meg
R_PD_718 368 0 100meg
R_PD_719 35 0 100meg
R_PD_720 n1828gat 0 100meg
R_PD_721 n1816gat 0 100meg
R_PD_722 II1899 0 100meg
R_PD_723 n1918gat 0 100meg
R_PD_724 II1183 0 100meg
R_PD_725 n3088gat 0 100meg
R_PD_726 n43gat 0 100meg
R_PD_727 n2084gat 0 100meg
R_PD_728 n719gat 0 100meg
R_PD_729 n3150gat 0 100meg
R_PD_730 188 0 100meg
R_PD_731 114 0 100meg
R_PD_732 145 0 100meg
R_PD_733 206 0 100meg
R_PD_734 II687 0 100meg
R_PD_735 n682gat 0 100meg
R_PD_736 CK 0 100meg
R_PD_737 n3074gat 0 100meg
R_PD_738 218 0 100meg
R_PD_739 387 0 100meg
R_PD_740 n3097gat 0 100meg
R_PD_741 n3143gat 0 100meg
R_PD_742 385 0 100meg
R_PD_743 n2928gat 0 100meg
R_PD_744 n2952gat 0 100meg
R_PD_745 II1407 0 100meg
R_PD_746 n3098gat 0 100meg
R_PD_747 n2897gat 0 100meg
R_PD_748 197 0 100meg
R_PD_749 n3132gat 0 100meg
R_PD_750 II921 0 100meg
R_PD_751 n1674gat 0 100meg
R_PD_752 n3130gat 0 100meg
R_PD_753 47 0 100meg
R_PD_754 II726 0 100meg
R_PD_755 326 0 100meg
R_PD_756 n2894gat 0 100meg
R_PD_757 63 0 100meg
R_PD_758 81 0 100meg
R_PD_759 n1858gat 0 100meg
R_PD_760 42 0 100meg
R_PD_761 315 0 100meg
R_PD_762 n2971gat 0 100meg
R_PD_763 336 0 100meg
R_PD_764 333 0 100meg
R_PD_765 123 0 100meg
R_PD_766 25 0 100meg
R_PD_767 n2123gat 0 100meg
R_PD_768 n1787gat 0 100meg
R_PD_769 359 0 100meg
R_PD_770 n2458gat 0 100meg
R_PD_771 n1685gat 0 100meg
R_PD_772 305 0 100meg
R_PD_773 n672gat 0 100meg
R_PD_774 284 0 100meg
R_PD_775 n2284gat 0 100meg
R_PD_776 n3093gat 0 100meg
R_PD_777 289 0 100meg
R_PD_778 n1793gat 0 100meg
R_PD_779 n1495gat 0 100meg
R_PD_780 334 0 100meg
R_PD_781 n2095gat 0 100meg
R_PD_782 n2108gat 0 100meg
R_PD_783 196 0 100meg
R_PD_784 268 0 100meg
R_PD_785 270 0 100meg
R_PD_786 n3049gat 0 100meg
R_PD_787 n2911gat 0 100meg
R_PD_788 373 0 100meg
R_PD_789 19 0 100meg
R_PD_790 n2119gat 0 100meg
R_PD_791 n3080gat 0 100meg
R_PD_792 250 0 100meg
R_PD_793 361 0 100meg
R_PD_794 n3105gat 0 100meg
R_PD_795 n2983gat 0 100meg
R_PD_796 n1524gat 0 100meg
R_PD_797 129 0 100meg
R_PD_798 95 0 100meg
R_PD_799 329 0 100meg
R_PD_800 n3131gat 0 100meg
R_PD_801 n2033gat 0 100meg
R_PD_802 n3064gat 0 100meg
R_PD_803 352 0 100meg
R_PD_804 n3111gat 0 100meg
R_PD_805 n2201gat 0 100meg
R_PD_806 353 0 100meg
R_PD_807 n1613gat 0 100meg
R_PD_808 Vdd 0 100meg
R_PD_809 n621gat 0 100meg
R_PD_810 n3085gat 0 100meg
R_PD_811 345 0 100meg
R_PD_812 320 0 100meg
R_PD_813 91 0 100meg
R_PD_814 380 0 100meg
R_PD_815 282 0 100meg
R_PD_816 388 0 100meg
R_PD_817 11 0 100meg
R_PD_818 133 0 100meg
R_PD_819 II2044 0 100meg
R_PD_820 II1011 0 100meg

* Transient Simulation Directive
.TRAN 100p 10n
