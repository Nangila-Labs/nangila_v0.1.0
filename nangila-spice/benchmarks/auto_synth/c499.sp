* Nangila SPICE Auto-Synthesized Netlist
.SUBCKT INV_X1 A Z
M1 Z A 0 0 NMOS W=0.2u L=0.05u
M2 Z A 1 1 PMOS W=0.4u L=0.05u
.ENDS

.SUBCKT NAND2_X1 A1 A2 Z
M1 Z A1 1 1 PMOS W=0.4u L=0.05u
M2 Z A2 1 1 PMOS W=0.4u L=0.05u
M3 Z A1 int 0 NMOS W=0.2u L=0.05u
M4 int A2 0 0 NMOS W=0.2u L=0.05u
.ENDS

.SUBCKT AND2_X1 A1 A2 Z
X1 A1 A2 Z_bar NAND2_X1
X2 Z_bar Z INV_X1
.ENDS

.SUBCKT NOR2_X1 A1 A2 Z
M1 int1 A1 1 1 PMOS W=0.4u L=0.05u
M2 Z A2 int1 1 PMOS W=0.4u L=0.05u
M3 Z A1 0 0 NMOS W=0.2u L=0.05u
M4 Z A2 0 0 NMOS W=0.2u L=0.05u
.ENDS

.SUBCKT OR2_X1 A1 A2 Z
X1 A1 A2 Z_bar NOR2_X1
X2 Z_bar Z INV_X1
.ENDS

.SUBCKT XOR2_X1 A1 A2 Z
X1 A1 A2 int1 AND2_X1
X2 A1 A2 int2 NOR2_X1
X3 int1 int2 int3 NOR2_X1
X4 int3 Z INV_X1
.ENDS

.SUBCKT XNOR2_X1 A B Z
X1 A B Z_int XOR2_X1
X2 Z_int Z INV_X1
.ENDS

.SUBCKT BUF_X1 A Z
X1 A Z_bar INV_X1
X2 Z_bar Z INV_X1
.ENDS

.SUBCKT OAI21_X1 A B C Z
X1 A B C Z_bar AOI21_X1
X2 Z_bar Z INV_X1
.ENDS

.SUBCKT AOI21_X1 A B C Z
M1 Z A int1 1 PMOS W=0.4u L=0.05u
M2 int1 B 1 1 PMOS W=0.4u L=0.05u
M3 Z C 1 1 PMOS W=0.4u L=0.05u
M4 Z A 0 0 NMOS W=0.2u L=0.05u
M5 Z B 0 0 NMOS W=0.2u L=0.05u
M6 Z C 0 0 NMOS W=0.2u L=0.05u
.ENDS

.SUBCKT NAND3_X1 A1 A2 A3 Z
X1 A1 A2 int1 AND2_X1
X2 int1 A3 Z NAND2_X1
.ENDS

.SUBCKT AND3_X1 A1 A2 A3 Z
X1 A1 A2 A3 Z_bar NAND3_X1
X2 Z_bar Z INV_X1
.ENDS

.SUBCKT NOR3_X1 A1 A2 A3 Z
X1 A1 A2 int1 OR2_X1
X2 int1 A3 Z NOR2_X1
.ENDS

.SUBCKT OR3_X1 A1 A2 A3 Z
X1 A1 A2 A3 Z_bar NOR3_X1
X2 Z_bar Z INV_X1
.ENDS

.SUBCKT NAND4_X1 A1 A2 A3 A4 Z
X1 A1 A2 A3 int1 AND3_X1
X2 int1 A4 Z NAND2_X1
.ENDS

.SUBCKT AND4_X1 A1 A2 A3 A4 Z
X1 A1 A2 A3 A4 Z_bar NAND4_X1
X2 Z_bar Z INV_X1
.ENDS

.SUBCKT NOR4_X1 A1 A2 A3 A4 Z
X1 A1 A2 A3 int1 OR3_X1
X2 int1 A4 Z NOR2_X1
.ENDS

.SUBCKT OR4_X1 A1 A2 A3 A4 Z
X1 A1 A2 A3 A4 Z_bar NOR4_X1
X2 Z_bar Z INV_X1
.ENDS

.SUBCKT AOI22_X1 A B C D Z
X1 A B int1 AND2_X1
X2 C D int2 AND2_X1
X3 int1 int2 Z NOR2_X1
.ENDS

.SUBCKT OAI22_X1 A B C D Z
X1 A B int1 OR2_X1
X2 C D int2 OR2_X1
X3 int1 int2 Z NAND2_X1
.ENDS

.SUBCKT AOI211_X1 A B C D Z
X1 A B int1 AND2_X1
X2 int1 C D Z NOR3_X1
.ENDS

.SUBCKT OAI211_X1 A B C D Z
X1 A B int1 OR2_X1
X2 int1 C D Z NAND3_X1
.ENDS

.SUBCKT OAI33_X1 A B C D E F Z
X1 A B C int1 OR3_X1
X2 D E F int2 OR3_X1
X3 int1 int2 Z NAND2_X1
.ENDS

.SUBCKT AOI33_X1 A B C D E F Z
X1 A B C int1 AND3_X1
X2 D E F int2 AND3_X1
X3 int1 int2 Z NOR2_X1
.ENDS

.SUBCKT MUX2_X1 A B S Z
X1 S S_bar INV_X1
X2 A S_bar int1 AND2_X1
X3 B S int2 AND2_X1
X4 int1 int2 Z OR2_X1
.ENDS

.SUBCKT DFF_X1 D C Q QN
X1 D Q_int INV_X1
X2 Q_int Q INV_X1
X3 Q_int QN INV_X1
.ENDS

.SUBCKT DFFR_X1 D C RN Q QN
X1 D Q_int INV_X1
X2 Q_int Q INV_X1
X3 Q_int QN INV_X1
.ENDS

.SUBCKT DFFS_X1 C D Q QN SN
X1 D Q_int INV_X1
X2 Q_int Q INV_X1
X3 Q_int QN INV_X1
.ENDS

.SUBCKT DFFRS_X1 C D Q QN RN SN
X1 D Q_int INV_X1
X2 Q_int Q INV_X1
X3 Q_int QN INV_X1
.ENDS

* Provide VDD power source explicitly
Vvdd 1 0 1.8

* Auto-extracted Inputs:
V_N1 N1 0 1.8
V_N5 N5 0 0.0
V_N9 N9 0 1.8
V_N13 N13 0 0.0
V_N17 N17 0 1.8
V_N21 N21 0 0.0
V_N25 N25 0 1.8
V_N29 N29 0 0.0
V_N33 N33 0 1.8
V_N37 N37 0 0.0
V_N41 N41 0 1.8
V_N45 N45 0 0.0
V_N49 N49 0 1.8
V_N53 N53 0 0.0
V_N57 N57 0 1.8
V_N61 N61 0 0.0
V_N65 N65 0 1.8
V_N69 N69 0 0.0
V_N73 N73 0 1.8
V_N77 N77 0 0.0
V_N81 N81 0 1.8
V_N85 N85 0 0.0
V_N89 N89 0 1.8
V_N93 N93 0 0.0
V_N97 N97 0 1.8
V_N101 N101 0 0.0
V_N105 N105 0 1.8
V_N109 N109 0 0.0
V_N113 N113 0 1.8
V_N117 N117 0 0.0
V_N121 N121 0 1.8
V_N125 N125 0 0.0
V_N129 N129 0 1.8
V_N130 N130 0 0.0
V_N131 N131 0 1.8
V_N132 N132 0 0.0
V_N133 N133 0 1.8
V_N134 N134 0 0.0
V_N135 N135 0 1.8
V_N136 N136 0 0.0
V_N137 N137 0 1.8

* Yosys Generated Netlist:
* SPICE netlist generated by Yosys 0.62 (git sha1 7326bb7d6641500ecb285c291a54a662cb1e76cf, clang++ 17.0.0 -fPIC -O3)

X0 N33 N49 1 XNOR2_X1
X1 N129 N137 2 NAND2_X1
X2 N1 N17 3 XNOR2_X1
X3 1 3 4 XNOR2_X1
X4 2 4 5 XNOR2_X1
X5 N73 N77 6 XOR2_X1
X6 N65 N69 7 XNOR2_X1
X7 6 7 8 XNOR2_X1
X8 N89 N93 9 XNOR2_X1
X9 N81 N85 10 XNOR2_X1
X10 9 10 11 XNOR2_X1
X11 8 11 12 XNOR2_X1
X12 5 12 13 XOR2_X1
X13 5 12 14 XNOR2_X1
X14 N97 N113 15 XNOR2_X1
X15 N137 N133 16 NAND2_X1
X16 N65 N81 17 XNOR2_X1
X17 16 17 18 XNOR2_X1
X18 15 18 19 XNOR2_X1
X19 N9 N13 20 XOR2_X1
X20 N1 N5 21 XNOR2_X1
X21 20 21 22 XNOR2_X1
X22 N25 N29 23 XNOR2_X1
X23 N17 N21 24 XNOR2_X1
X24 23 24 25 XNOR2_X1
X25 22 25 26 XNOR2_X1
X26 19 26 27 XNOR2_X1
X27 N101 N117 28 XNOR2_X1
X28 N137 N134 29 NAND2_X1
X29 N69 N85 30 XNOR2_X1
X30 29 30 31 XNOR2_X1
X31 28 31 32 XNOR2_X1
X32 N41 N45 33 XNOR2_X1
X33 N33 N37 34 XNOR2_X1
X34 33 34 35 XNOR2_X1
X35 N57 N61 36 XNOR2_X1
X36 N49 N53 37 XNOR2_X1
X37 36 37 38 XNOR2_X1
X38 35 38 39 XOR2_X1
X39 32 39 40 XNOR2_X1
X40 40 41 INV_X1
X41 27 41 42 NAND2_X1
X42 N105 N121 43 XNOR2_X1
X43 N137 N135 44 NAND2_X1
X44 N73 N89 45 XNOR2_X1
X45 43 45 46 XNOR2_X1
X46 44 46 47 XNOR2_X1
X47 22 35 48 XNOR2_X1
X48 47 48 49 XNOR2_X1
X49 49 50 INV_X1
X50 N109 N125 51 XNOR2_X1
X51 N137 N136 52 NAND2_X1
X52 N77 N93 53 XNOR2_X1
X53 51 53 54 XNOR2_X1
X54 52 54 55 XNOR2_X1
X55 25 38 56 XOR2_X1
X56 55 56 57 XNOR2_X1
X57 57 58 INV_X1
X58 49 58 59 NAND2_X1
X59 N37 N53 60 XNOR2_X1
X60 N137 N130 61 NAND2_X1
X61 N5 N21 62 XNOR2_X1
X62 61 62 63 XNOR2_X1
X63 60 63 64 XNOR2_X1
X64 N121 N125 65 XOR2_X1
X65 N113 N117 66 XNOR2_X1
X66 65 66 67 XNOR2_X1
X67 N105 N109 68 XNOR2_X1
X68 N97 N101 69 XNOR2_X1
X69 68 69 70 XNOR2_X1
X70 67 70 71 XNOR2_X1
X71 64 71 72 XOR2_X1
X72 64 71 73 XNOR2_X1
X73 13 73 74 NAND2_X1
X74 N137 N131 75 NAND2_X1
X75 8 75 76 XNOR2_X1
X76 N41 N57 77 XNOR2_X1
X77 N9 N25 78 XNOR2_X1
X78 77 78 79 XNOR2_X1
X79 70 79 80 XNOR2_X1
X80 76 80 81 XNOR2_X1
X81 14 72 81 82 NOR3_X1
X82 74 81 83 OR2_X1
X83 14 72 84 NAND2_X1
X84 13 73 81 85 NOR3_X1
X85 81 84 86 OR2_X1
X86 N137 N132 87 NAND2_X1
X87 11 87 88 XNOR2_X1
X88 N45 N61 89 XOR2_X1
X89 N13 N29 90 XNOR2_X1
X90 89 90 91 XNOR2_X1
X91 67 91 92 XNOR2_X1
X92 88 92 93 XOR2_X1
X93 88 92 94 XNOR2_X1
X94 94 85 82 95 OAI21_X1
X95 81 94 96 NAND2_X1
X96 81 94 97 XNOR2_X1
X97 13 72 97 98 NAND3_X1
X98 42 59 95 98 99 AOI211_X1
X99 14 99 100 NAND2_X1
X100 N1 100 N724 XNOR2_X1
X101 73 99 101 NAND2_X1
X102 N5 101 N725 XNOR2_X1
X103 81 99 102 NAND2_X1
X104 N9 102 N726 XNOR2_X1
X105 93 99 103 NAND2_X1
X106 N13 103 N727 XNOR2_X1
X107 50 57 104 NAND2_X1
X108 42 104 98 95 105 AOI211_X1
X109 14 105 106 NAND2_X1
X110 N17 106 N728 XNOR2_X1
X111 73 105 107 NAND2_X1
X112 N21 107 N729 XNOR2_X1
X113 81 105 108 NAND2_X1
X114 N25 108 N730 XNOR2_X1
X115 93 105 109 NAND2_X1
X116 N29 109 N731 XNOR2_X1
X117 27 41 110 OR2_X1
X118 59 110 98 95 111 AOI211_X1
X119 14 111 112 NAND2_X1
X120 N33 112 N732 XNOR2_X1
X121 73 111 113 NAND2_X1
X122 N37 113 N733 XNOR2_X1
X123 81 111 114 NAND2_X1
X124 N41 114 N734 XNOR2_X1
X125 93 111 115 NAND2_X1
X126 N45 115 N735 XNOR2_X1
X127 104 110 95 98 116 AOI211_X1
X128 14 116 117 NAND2_X1
X129 N49 117 N736 XNOR2_X1
X130 73 116 118 NAND2_X1
X131 N53 118 N737 XNOR2_X1
X132 81 116 119 NAND2_X1
X133 N57 119 N738 XNOR2_X1
X134 93 116 120 NAND2_X1
X135 N61 120 N739 XNOR2_X1
X136 27 40 121 XOR2_X1
X137 50 58 121 122 NAND3_X1
X138 49 57 123 XNOR2_X1
X139 27 40 123 124 OR3_X1
X140 84 96 122 124 125 AOI211_X1
X141 27 125 126 NAND2_X1
X142 N65 126 N740 XNOR2_X1
X143 40 125 127 NAND2_X1
X144 N69 127 N741 XNOR2_X1
X145 49 125 128 NAND2_X1
X146 N73 128 N742 XNOR2_X1
X147 57 125 129 NAND2_X1
X148 N77 129 N743 XNOR2_X1
X149 86 94 122 124 130 AOI211_X1
X150 27 130 131 NAND2_X1
X151 N81 131 N744 XNOR2_X1
X152 40 130 132 NAND2_X1
X153 N85 132 N745 XNOR2_X1
X154 49 130 133 NAND2_X1
X155 N89 133 N746 XNOR2_X1
X156 57 130 134 NAND2_X1
X157 N93 134 N747 XNOR2_X1
X158 74 96 122 124 135 AOI211_X1
X159 27 135 136 NAND2_X1
X160 N97 136 N748 XNOR2_X1
X161 40 135 137 NAND2_X1
X162 N101 137 N749 XNOR2_X1
X163 49 135 138 NAND2_X1
X164 N105 138 N750 XNOR2_X1
X165 57 135 139 NAND2_X1
X166 N109 139 N751 XNOR2_X1
X167 83 94 122 124 140 AOI211_X1
X168 27 140 141 NAND2_X1
X169 N113 141 N752 XNOR2_X1
X170 40 140 142 NAND2_X1
X171 N117 142 N753 XNOR2_X1
X172 49 140 143 NAND2_X1
X173 N121 143 N754 XNOR2_X1
X174 57 140 144 NAND2_X1
X175 N125 144 N755 XNOR2_X1

************************
* end of SPICE netlist *
************************

* Anti-Floating Pull-Downs (GMIN)
R_PD_0 96 0 100meg
R_PD_1 N81 0 100meg
R_PD_2 101 0 100meg
R_PD_3 N49 0 100meg
R_PD_4 N137 0 100meg
R_PD_5 N744 0 100meg
R_PD_6 117 0 100meg
R_PD_7 N130 0 100meg
R_PD_8 38 0 100meg
R_PD_9 21 0 100meg
R_PD_10 N739 0 100meg
R_PD_11 69 0 100meg
R_PD_12 50 0 100meg
R_PD_13 110 0 100meg
R_PD_14 109 0 100meg
R_PD_15 119 0 100meg
R_PD_16 N751 0 100meg
R_PD_17 60 0 100meg
R_PD_18 65 0 100meg
R_PD_19 N53 0 100meg
R_PD_20 72 0 100meg
R_PD_21 N109 0 100meg
R_PD_22 24 0 100meg
R_PD_23 55 0 100meg
R_PD_24 57 0 100meg
R_PD_25 87 0 100meg
R_PD_26 N726 0 100meg
R_PD_27 9 0 100meg
R_PD_28 39 0 100meg
R_PD_29 N33 0 100meg
R_PD_30 12 0 100meg
R_PD_31 18 0 100meg
R_PD_32 76 0 100meg
R_PD_33 136 0 100meg
R_PD_34 140 0 100meg
R_PD_35 126 0 100meg
R_PD_36 137 0 100meg
R_PD_37 N136 0 100meg
R_PD_38 23 0 100meg
R_PD_39 30 0 100meg
R_PD_40 103 0 100meg
R_PD_41 66 0 100meg
R_PD_42 40 0 100meg
R_PD_43 N738 0 100meg
R_PD_44 N755 0 100meg
R_PD_45 51 0 100meg
R_PD_46 N45 0 100meg
R_PD_47 N737 0 100meg
R_PD_48 132 0 100meg
R_PD_49 N113 0 100meg
R_PD_50 N9 0 100meg
R_PD_51 29 0 100meg
R_PD_52 52 0 100meg
R_PD_53 90 0 100meg
R_PD_54 43 0 100meg
R_PD_55 26 0 100meg
R_PD_56 83 0 100meg
R_PD_57 102 0 100meg
R_PD_58 6 0 100meg
R_PD_59 N13 0 100meg
R_PD_60 N734 0 100meg
R_PD_61 107 0 100meg
R_PD_62 135 0 100meg
R_PD_63 64 0 100meg
R_PD_64 1 0 100meg
R_PD_65 N29 0 100meg
R_PD_66 100 0 100meg
R_PD_67 N93 0 100meg
R_PD_68 61 0 100meg
R_PD_69 2 0 100meg
R_PD_70 116 0 100meg
R_PD_71 73 0 100meg
R_PD_72 N733 0 100meg
R_PD_73 48 0 100meg
R_PD_74 N69 0 100meg
R_PD_75 N736 0 100meg
R_PD_76 N5 0 100meg
R_PD_77 75 0 100meg
R_PD_78 106 0 100meg
R_PD_79 58 0 100meg
R_PD_80 N740 0 100meg
R_PD_81 131 0 100meg
R_PD_82 10 0 100meg
R_PD_83 141 0 100meg
R_PD_84 144 0 100meg
R_PD_85 N41 0 100meg
R_PD_86 N732 0 100meg
R_PD_87 89 0 100meg
R_PD_88 115 0 100meg
R_PD_89 127 0 100meg
R_PD_90 N747 0 100meg
R_PD_91 N748 0 100meg
R_PD_92 N753 0 100meg
R_PD_93 82 0 100meg
R_PD_94 105 0 100meg
R_PD_95 121 0 100meg
R_PD_96 56 0 100meg
R_PD_97 97 0 100meg
R_PD_98 N57 0 100meg
R_PD_99 68 0 100meg
R_PD_100 74 0 100meg
R_PD_101 15 0 100meg
R_PD_102 46 0 100meg
R_PD_103 85 0 100meg
R_PD_104 37 0 100meg
R_PD_105 4 0 100meg
R_PD_106 134 0 100meg
R_PD_107 N1 0 100meg
R_PD_108 3 0 100meg
R_PD_109 79 0 100meg
R_PD_110 20 0 100meg
R_PD_111 N131 0 100meg
R_PD_112 N125 0 100meg
R_PD_113 124 0 100meg
R_PD_114 N85 0 100meg
R_PD_115 7 0 100meg
R_PD_116 8 0 100meg
R_PD_117 N752 0 100meg
R_PD_118 16 0 100meg
R_PD_119 70 0 100meg
R_PD_120 99 0 100meg
R_PD_121 N741 0 100meg
R_PD_122 77 0 100meg
R_PD_123 54 0 100meg
R_PD_124 N61 0 100meg
R_PD_125 108 0 100meg
R_PD_126 35 0 100meg
R_PD_127 N730 0 100meg
R_PD_128 112 0 100meg
R_PD_129 142 0 100meg
R_PD_130 86 0 100meg
R_PD_131 N121 0 100meg
R_PD_132 N117 0 100meg
R_PD_133 N97 0 100meg
R_PD_134 N65 0 100meg
R_PD_135 N133 0 100meg
R_PD_136 17 0 100meg
R_PD_137 28 0 100meg
R_PD_138 N132 0 100meg
R_PD_139 114 0 100meg
R_PD_140 34 0 100meg
R_PD_141 36 0 100meg
R_PD_142 120 0 100meg
R_PD_143 N77 0 100meg
R_PD_144 118 0 100meg
R_PD_145 138 0 100meg
R_PD_146 N89 0 100meg
R_PD_147 33 0 100meg
R_PD_148 N731 0 100meg
R_PD_149 98 0 100meg
R_PD_150 N37 0 100meg
R_PD_151 N135 0 100meg
R_PD_152 N745 0 100meg
R_PD_153 N750 0 100meg
R_PD_154 53 0 100meg
R_PD_155 59 0 100meg
R_PD_156 94 0 100meg
R_PD_157 113 0 100meg
R_PD_158 47 0 100meg
R_PD_159 128 0 100meg
R_PD_160 63 0 100meg
R_PD_161 81 0 100meg
R_PD_162 42 0 100meg
R_PD_163 88 0 100meg
R_PD_164 N729 0 100meg
R_PD_165 N134 0 100meg
R_PD_166 125 0 100meg
R_PD_167 93 0 100meg
R_PD_168 N727 0 100meg
R_PD_169 N754 0 100meg
R_PD_170 N17 0 100meg
R_PD_171 92 0 100meg
R_PD_172 123 0 100meg
R_PD_173 22 0 100meg
R_PD_174 25 0 100meg
R_PD_175 139 0 100meg
R_PD_176 N724 0 100meg
R_PD_177 80 0 100meg
R_PD_178 44 0 100meg
R_PD_179 45 0 100meg
R_PD_180 71 0 100meg
R_PD_181 N73 0 100meg
R_PD_182 32 0 100meg
R_PD_183 41 0 100meg
R_PD_184 130 0 100meg
R_PD_185 14 0 100meg
R_PD_186 104 0 100meg
R_PD_187 N101 0 100meg
R_PD_188 49 0 100meg
R_PD_189 62 0 100meg
R_PD_190 19 0 100meg
R_PD_191 122 0 100meg
R_PD_192 N749 0 100meg
R_PD_193 84 0 100meg
R_PD_194 N129 0 100meg
R_PD_195 111 0 100meg
R_PD_196 31 0 100meg
R_PD_197 N725 0 100meg
R_PD_198 N742 0 100meg
R_PD_199 N21 0 100meg
R_PD_200 129 0 100meg
R_PD_201 95 0 100meg
R_PD_202 27 0 100meg
R_PD_203 143 0 100meg
R_PD_204 67 0 100meg
R_PD_205 78 0 100meg
R_PD_206 N743 0 100meg
R_PD_207 N746 0 100meg
R_PD_208 N25 0 100meg
R_PD_209 N105 0 100meg
R_PD_210 91 0 100meg
R_PD_211 N735 0 100meg
R_PD_212 13 0 100meg
R_PD_213 11 0 100meg
R_PD_214 133 0 100meg
R_PD_215 5 0 100meg
R_PD_216 N728 0 100meg

* Transient Simulation Directive
.TRAN 100p 10n
