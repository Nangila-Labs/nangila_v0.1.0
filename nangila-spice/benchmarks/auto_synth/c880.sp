* Nangila SPICE Auto-Synthesized Netlist
.SUBCKT INV_X1 A Z
M1 Z A 0 0 NMOS W=0.2u L=0.05u
M2 Z A 1 1 PMOS W=0.4u L=0.05u
.ENDS

.SUBCKT NAND2_X1 A1 A2 Z
M1 Z A1 1 1 PMOS W=0.4u L=0.05u
M2 Z A2 1 1 PMOS W=0.4u L=0.05u
M3 Z A1 int 0 NMOS W=0.2u L=0.05u
M4 int A2 0 0 NMOS W=0.2u L=0.05u
.ENDS

.SUBCKT AND2_X1 A1 A2 Z
X1 A1 A2 Z_bar NAND2_X1
X2 Z_bar Z INV_X1
.ENDS

.SUBCKT NOR2_X1 A1 A2 Z
M1 int1 A1 1 1 PMOS W=0.4u L=0.05u
M2 Z A2 int1 1 PMOS W=0.4u L=0.05u
M3 Z A1 0 0 NMOS W=0.2u L=0.05u
M4 Z A2 0 0 NMOS W=0.2u L=0.05u
.ENDS

.SUBCKT OR2_X1 A1 A2 Z
X1 A1 A2 Z_bar NOR2_X1
X2 Z_bar Z INV_X1
.ENDS

.SUBCKT XOR2_X1 A1 A2 Z
X1 A1 A2 int1 AND2_X1
X2 A1 A2 int2 NOR2_X1
X3 int1 int2 int3 NOR2_X1
X4 int3 Z INV_X1
.ENDS

.SUBCKT XNOR2_X1 A B Z
X1 A B Z_int XOR2_X1
X2 Z_int Z INV_X1
.ENDS

.SUBCKT BUF_X1 A Z
X1 A Z_bar INV_X1
X2 Z_bar Z INV_X1
.ENDS

.SUBCKT OAI21_X1 A B C Z
X1 A B C Z_bar AOI21_X1
X2 Z_bar Z INV_X1
.ENDS

.SUBCKT AOI21_X1 A B C Z
M1 Z A int1 1 PMOS W=0.4u L=0.05u
M2 int1 B 1 1 PMOS W=0.4u L=0.05u
M3 Z C 1 1 PMOS W=0.4u L=0.05u
M4 Z A 0 0 NMOS W=0.2u L=0.05u
M5 Z B 0 0 NMOS W=0.2u L=0.05u
M6 Z C 0 0 NMOS W=0.2u L=0.05u
.ENDS

.SUBCKT NAND3_X1 A1 A2 A3 Z
X1 A1 A2 int1 AND2_X1
X2 int1 A3 Z NAND2_X1
.ENDS

.SUBCKT AND3_X1 A1 A2 A3 Z
X1 A1 A2 A3 Z_bar NAND3_X1
X2 Z_bar Z INV_X1
.ENDS

.SUBCKT NOR3_X1 A1 A2 A3 Z
X1 A1 A2 int1 OR2_X1
X2 int1 A3 Z NOR2_X1
.ENDS

.SUBCKT OR3_X1 A1 A2 A3 Z
X1 A1 A2 A3 Z_bar NOR3_X1
X2 Z_bar Z INV_X1
.ENDS

.SUBCKT NAND4_X1 A1 A2 A3 A4 Z
X1 A1 A2 A3 int1 AND3_X1
X2 int1 A4 Z NAND2_X1
.ENDS

.SUBCKT AND4_X1 A1 A2 A3 A4 Z
X1 A1 A2 A3 A4 Z_bar NAND4_X1
X2 Z_bar Z INV_X1
.ENDS

.SUBCKT NOR4_X1 A1 A2 A3 A4 Z
X1 A1 A2 A3 int1 OR3_X1
X2 int1 A4 Z NOR2_X1
.ENDS

.SUBCKT OR4_X1 A1 A2 A3 A4 Z
X1 A1 A2 A3 A4 Z_bar NOR4_X1
X2 Z_bar Z INV_X1
.ENDS

.SUBCKT AOI22_X1 A B C D Z
X1 A B int1 AND2_X1
X2 C D int2 AND2_X1
X3 int1 int2 Z NOR2_X1
.ENDS

.SUBCKT OAI22_X1 A B C D Z
X1 A B int1 OR2_X1
X2 C D int2 OR2_X1
X3 int1 int2 Z NAND2_X1
.ENDS

.SUBCKT AOI211_X1 A B C D Z
X1 A B int1 AND2_X1
X2 int1 C D Z NOR3_X1
.ENDS

.SUBCKT OAI211_X1 A B C D Z
X1 A B int1 OR2_X1
X2 int1 C D Z NAND3_X1
.ENDS

.SUBCKT OAI33_X1 A B C D E F Z
X1 A B C int1 OR3_X1
X2 D E F int2 OR3_X1
X3 int1 int2 Z NAND2_X1
.ENDS

.SUBCKT AOI33_X1 A B C D E F Z
X1 A B C int1 AND3_X1
X2 D E F int2 AND3_X1
X3 int1 int2 Z NOR2_X1
.ENDS

.SUBCKT MUX2_X1 A B S Z
X1 S S_bar INV_X1
X2 A S_bar int1 AND2_X1
X3 B S int2 AND2_X1
X4 int1 int2 Z OR2_X1
.ENDS

.SUBCKT DFF_X1 D C Q QN
X1 D Q_int INV_X1
X2 Q_int Q INV_X1
X3 Q_int QN INV_X1
.ENDS

.SUBCKT DFFR_X1 D C RN Q QN
X1 D Q_int INV_X1
X2 Q_int Q INV_X1
X3 Q_int QN INV_X1
.ENDS

.SUBCKT DFFS_X1 C D Q QN SN
X1 D Q_int INV_X1
X2 Q_int Q INV_X1
X3 Q_int QN INV_X1
.ENDS

.SUBCKT DFFRS_X1 C D Q QN RN SN
X1 D Q_int INV_X1
X2 Q_int Q INV_X1
X3 Q_int QN INV_X1
.ENDS

* Provide VDD power source explicitly
Vvdd 1 0 1.8

* Auto-extracted Inputs:
V_N1 N1 0 1.8
V_N8 N8 0 0.0
V_N13 N13 0 1.8
V_N17 N17 0 0.0
V_N26 N26 0 1.8
V_N29 N29 0 0.0
V_N36 N36 0 1.8
V_N42 N42 0 0.0
V_N51 N51 0 1.8
V_N55 N55 0 0.0
V_N59 N59 0 1.8
V_N68 N68 0 0.0
V_N72 N72 0 1.8
V_N73 N73 0 0.0
V_N74 N74 0 1.8
V_N75 N75 0 0.0
V_N80 N80 0 1.8
V_N85 N85 0 0.0
V_N86 N86 0 1.8
V_N87 N87 0 0.0
V_N88 N88 0 1.8
V_N89 N89 0 0.0
V_N90 N90 0 1.8
V_N91 N91 0 0.0
V_N96 N96 0 1.8
V_N101 N101 0 0.0
V_N106 N106 0 1.8
V_N111 N111 0 0.0
V_N116 N116 0 1.8
V_N121 N121 0 0.0
V_N126 N126 0 1.8
V_N130 N130 0 0.0
V_N135 N135 0 1.8
V_N138 N138 0 0.0
V_N143 N143 0 1.8
V_N146 N146 0 0.0
V_N149 N149 0 1.8
V_N152 N152 0 0.0
V_N153 N153 0 1.8
V_N156 N156 0 0.0
V_N159 N159 0 1.8
V_N165 N165 0 0.0
V_N171 N171 0 1.8
V_N177 N177 0 0.0
V_N183 N183 0 1.8
V_N189 N189 0 0.0
V_N195 N195 0 1.8
V_N201 N201 0 0.0
V_N207 N207 0 1.8
V_N210 N210 0 0.0
V_N219 N219 0 1.8
V_N228 N228 0 0.0
V_N237 N237 0 1.8
V_N246 N246 0 0.0
V_N255 N255 0 1.8
V_N259 N259 0 0.0
V_N260 N260 0 1.8
V_N261 N261 0 0.0
V_N267 N267 0 1.8
V_N268 N268 0 0.0

* Yosys Generated Netlist:
* SPICE netlist generated by Yosys 0.62 (git sha1 7326bb7d6641500ecb285c291a54a662cb1e76cf, clang++ 17.0.0 -fPIC -O3)

X0 N219 1 INV_X1
X1 N1 2 INV_X1
X2 N201 3 INV_X1
X3 N268 4 INV_X1
X4 N143 5 INV_X1
X5 N146 6 INV_X1
X6 N149 7 INV_X1
X7 N237 8 INV_X1
X8 N1 N8 9 NAND2_X1
X9 N17 N13 N1 N8 N418 AND4_X1
X10 N1 N26 N51 10 NAND3_X1
X11 10 N447 INV_X1
X12 N42 N29 N75 N388 AND3_X1
X13 N29 N80 N36 N389 AND3_X1
X14 N42 N29 N36 11 NAND3_X1
X15 11 N390 INV_X1
X16 N85 N86 N391 AND2_X1
X17 N17 N13 N1 N26 12 AND4_X1
X18 11 12 N419 NAND2_X1
X19 N87 N88 13 OR2_X1
X20 N89 13 N450 AND2_X1
X21 N90 13 N423 AND2_X1
X22 N390 12 N446 NAND2_X1
X23 N59 N80 N75 N420 NAND3_X1
X24 N59 N80 N36 N421 NAND3_X1
X25 N59 N42 N36 N422 NAND3_X1
X26 N13 N1 N8 N55 14 AND4_X1
X27 N68 N29 14 N448 AND3_X1
X28 N59 N68 N74 14 N449 AND4_X1
X29 N17 N42 15 XNOR2_X1
X30 N59 N156 16 NAND2_X1
X31 N59 N42 N75 17 AND3_X1
X32 N17 N51 18 NAND2_X1
X33 10 15 16 17 18 9 19 OAI33_X1
X34 N17 N447 16 20 AND3_X1
X35 2 20 21 NOR2_X1
X36 N153 20 2 22 OAI21_X1
X37 N29 N80 N75 N447 23 AND4_X1
X38 N55 4 24 AND2_X1
X39 23 24 25 NAND2_X1
X40 N126 19 23 24 26 AOI22_X1
X41 22 26 27 NAND2_X1
X42 3 22 26 28 AOI21_X1
X43 3 22 26 29 NAND3_X1
X44 3 27 30 XNOR2_X1
X45 N261 30 31 XNOR2_X1
X46 N237 28 32 NAND2_X1
X47 N59 N42 N68 N73 33 AND4_X1
X48 N72 14 33 34 AND3_X1
X49 N121 N210 N255 N267 34 N201 35 AOI222_X1
X50 35 36 INV_X1
X51 36 30 N228 N246 27 37 AOI221_X1
X52 32 37 1 31 N850 OAI211_X1
X53 N111 19 38 NAND2_X1
X54 5 21 39 NOR2_X1
X55 25 38 40 NAND2_X1
X56 39 40 41 OR2_X1
X57 N183 41 42 AND2_X1
X58 N183 41 43 XNOR2_X1
X59 N116 19 44 NAND2_X1
X60 25 44 6 21 45 OAI211_X1
X61 N189 45 46 AND2_X1
X62 N189 45 47 NOR2_X1
X63 N121 19 48 NAND2_X1
X64 25 48 7 21 49 OAI211_X1
X65 N195 49 50 NAND2_X1
X66 N195 49 51 NOR2_X1
X67 29 28 N261 52 OAI21_X1
X68 51 52 50 53 AOI21_X1
X69 47 51 52 50 54 AOI211_X1
X70 46 54 55 NOR2_X1
X71 N228 55 N219 56 AOI21_X1
X72 N219 43 57 NAND2_X1
X73 N106 N210 34 N183 58 AOI22_X1
X74 58 59 INV_X1
X75 59 42 N237 N246 41 60 AOI221_X1
X76 60 57 55 43 56 N863 OAI221_X1
X77 46 47 61 NOR2_X1
X78 53 61 62 XNOR2_X1
X79 N228 61 63 NAND2_X1
X80 N189 34 45 N246 64 AOI22_X1
X81 N111 N210 N255 N259 N237 46 65 AOI222_X1
X82 63 64 65 66 AND3_X1
X83 66 62 1 N864 OAI21_X1
X84 N195 49 67 XOR2_X1
X85 52 67 68 XNOR2_X1
X86 N246 49 69 NAND2_X1
X87 N116 N210 N255 N260 34 N195 70 AOI222_X1
X88 69 70 8 50 71 OAI211_X1
X89 71 67 N228 N219 68 72 AOI221_X1
X90 72 N865 INV_X1
X91 N55 N447 16 73 AND3_X1
X92 N143 73 74 NAND2_X1
X93 N17 4 23 75 NAND3_X1
X94 75 76 INV_X1
X95 N8 N138 19 N91 77 AOI22_X1
X96 74 75 77 78 NAND3_X1
X97 N159 78 79 AND2_X1
X98 79 80 INV_X1
X99 N159 78 81 NOR2_X1
X100 N96 19 82 NAND2_X1
X101 N51 N138 N146 73 83 AOI22_X1
X102 82 83 84 NAND2_X1
X103 76 84 85 OR2_X1
X104 N165 85 86 AND2_X1
X105 N17 N138 N149 73 19 N101 87 AOI222_X1
X106 75 87 88 NAND2_X1
X107 N171 88 89 AND2_X1
X108 N171 88 90 NOR2_X1
X109 N138 N152 N153 73 19 N106 91 AOI222_X1
X110 75 91 92 NAND2_X1
X111 N177 92 93 AND2_X1
X112 93 94 INV_X1
X113 N177 92 95 NOR2_X1
X114 N183 39 40 42 46 54 96 OAI33_X1
X115 95 96 94 97 AOI21_X1
X116 90 95 96 94 98 AOI211_X1
X117 89 98 99 NOR2_X1
X118 N165 76 84 86 89 98 100 OAI33_X1
X119 81 100 80 N866 AOI21_X1
X120 93 95 101 NOR2_X1
X121 96 101 102 XOR2_X1
X122 N246 92 101 N228 103 AOI22_X1
X123 N101 N210 N237 93 34 N177 104 AOI222_X1
X124 103 104 1 102 N874 OAI211_X1
X125 79 81 105 NOR2_X1
X126 100 105 106 XOR2_X1
X127 N210 N268 N246 78 34 N159 107 AOI222_X1
X128 107 108 INV_X1
X129 108 79 N237 N228 105 109 AOI221_X1
X130 109 106 1 N878 OAI21_X1
X131 N165 85 110 XOR2_X1
X132 99 110 111 XOR2_X1
X133 N228 110 112 NAND2_X1
X134 N91 N210 34 N165 113 AOI22_X1
X135 113 114 INV_X1
X136 114 86 N237 N246 85 115 AOI221_X1
X137 112 115 1 111 N879 OAI211_X1
X138 89 90 116 NOR2_X1
X139 97 116 117 XNOR2_X1
X140 N96 N210 N246 88 34 N171 118 AOI222_X1
X141 118 119 INV_X1
X142 119 89 N237 N228 116 120 AOI221_X1
X143 120 117 1 N880 OAI21_X1
X144 N96 N130 121 XOR2_X1
X145 N91 121 122 XNOR2_X1
X146 N116 N135 123 XOR2_X1
X147 N111 123 124 XNOR2_X1
X148 N101 N106 125 XNOR2_X1
X149 N121 N126 126 XOR2_X1
X150 125 126 127 XNOR2_X1
X151 124 127 128 XNOR2_X1
X152 122 128 N767 XNOR2_X1
X153 N165 N130 129 XOR2_X1
X154 N159 129 130 XNOR2_X1
X155 N189 N207 131 XOR2_X1
X156 N183 131 132 XNOR2_X1
X157 N171 N177 133 XNOR2_X1
X158 N195 N201 134 XOR2_X1
X159 133 134 135 XNOR2_X1
X160 132 135 136 XNOR2_X1
X161 130 136 N768 XNOR2_X1
V0 N767 N660 DC 0
V1 N768 N661 DC 0
V2 N390 N273 DC 0
V3 N447 N276 DC 0
V4 N418 N342 DC 0
V5 N419 N344 DC 0
V6 N388 N290 DC 0
V7 N389 N291 DC 0
V8 N420 N351 DC 0
V9 N390 N292 DC 0
V10 N421 N353 DC 0
V11 N422 N354 DC 0
V12 N423 N356 DC 0
V13 N268 N369 DC 0
V14 N391 N297 DC 0
V15 N446 N392 DC 0
V16 N447 N393 DC 0
V17 N447 N399 DC 0
V18 N448 N401 DC 0
V19 N449 N402 DC 0
V20 N450 N403 DC 0
V21 N850 N811 DC 0
V22 N863 N837 DC 0
V23 N864 N838 DC 0
V24 N865 N839 DC 0
V25 N850 N840 DC 0
V26 N874 N854 DC 0
V27 N863 N855 DC 0
V28 N864 N856 DC 0
V29 N865 N857 DC 0
V30 N866 N858 DC 0
V31 N878 N867 DC 0
V32 N879 N868 DC 0
V33 N880 N869 DC 0
V34 N874 N870 DC 0
V35 N878 N875 DC 0
V36 N879 N876 DC 0
V37 N880 N877 DC 0

************************
* end of SPICE netlist *
************************

* Anti-Floating Pull-Downs (GMIN)
R_PD_0 N450 0 100meg
R_PD_1 96 0 100meg
R_PD_2 101 0 100meg
R_PD_3 N255 0 100meg
R_PD_4 117 0 100meg
R_PD_5 N130 0 100meg
R_PD_6 N88 0 100meg
R_PD_7 38 0 100meg
R_PD_8 N59 0 100meg
R_PD_9 21 0 100meg
R_PD_10 69 0 100meg
R_PD_11 N116 0 100meg
R_PD_12 N146 0 100meg
R_PD_13 50 0 100meg
R_PD_14 110 0 100meg
R_PD_15 109 0 100meg
R_PD_16 N391 0 100meg
R_PD_17 N421 0 100meg
R_PD_18 119 0 100meg
R_PD_19 60 0 100meg
R_PD_20 65 0 100meg
R_PD_21 72 0 100meg
R_PD_22 24 0 100meg
R_PD_23 55 0 100meg
R_PD_24 57 0 100meg
R_PD_25 87 0 100meg
R_PD_26 9 0 100meg
R_PD_27 N874 0 100meg
R_PD_28 39 0 100meg
R_PD_29 12 0 100meg
R_PD_30 18 0 100meg
R_PD_31 N189 0 100meg
R_PD_32 N863 0 100meg
R_PD_33 76 0 100meg
R_PD_34 136 0 100meg
R_PD_35 126 0 100meg
R_PD_36 N72 0 100meg
R_PD_37 N171 0 100meg
R_PD_38 N143 0 100meg
R_PD_39 23 0 100meg
R_PD_40 N259 0 100meg
R_PD_41 30 0 100meg
R_PD_42 N96 0 100meg
R_PD_43 103 0 100meg
R_PD_44 66 0 100meg
R_PD_45 40 0 100meg
R_PD_46 N126 0 100meg
R_PD_47 51 0 100meg
R_PD_48 132 0 100meg
R_PD_49 N423 0 100meg
R_PD_50 N87 0 100meg
R_PD_51 29 0 100meg
R_PD_52 52 0 100meg
R_PD_53 N866 0 100meg
R_PD_54 90 0 100meg
R_PD_55 102 0 100meg
R_PD_56 43 0 100meg
R_PD_57 26 0 100meg
R_PD_58 83 0 100meg
R_PD_59 127 0 100meg
R_PD_60 6 0 100meg
R_PD_61 N237 0 100meg
R_PD_62 N13 0 100meg
R_PD_63 N388 0 100meg
R_PD_64 N138 0 100meg
R_PD_65 107 0 100meg
R_PD_66 135 0 100meg
R_PD_67 64 0 100meg
R_PD_68 1 0 100meg
R_PD_69 N29 0 100meg
R_PD_70 100 0 100meg
R_PD_71 61 0 100meg
R_PD_72 2 0 100meg
R_PD_73 N42 0 100meg
R_PD_74 116 0 100meg
R_PD_75 73 0 100meg
R_PD_76 48 0 100meg
R_PD_77 N449 0 100meg
R_PD_78 N156 0 100meg
R_PD_79 N36 0 100meg
R_PD_80 N152 0 100meg
R_PD_81 N446 0 100meg
R_PD_82 75 0 100meg
R_PD_83 58 0 100meg
R_PD_84 106 0 100meg
R_PD_85 131 0 100meg
R_PD_86 10 0 100meg
R_PD_87 N864 0 100meg
R_PD_88 115 0 100meg
R_PD_89 89 0 100meg
R_PD_90 N201 0 100meg
R_PD_91 N55 0 100meg
R_PD_92 N210 0 100meg
R_PD_93 82 0 100meg
R_PD_94 105 0 100meg
R_PD_95 121 0 100meg
R_PD_96 56 0 100meg
R_PD_97 97 0 100meg
R_PD_98 N246 0 100meg
R_PD_99 N420 0 100meg
R_PD_100 N228 0 100meg
R_PD_101 N389 0 100meg
R_PD_102 68 0 100meg
R_PD_103 74 0 100meg
R_PD_104 15 0 100meg
R_PD_105 46 0 100meg
R_PD_106 85 0 100meg
R_PD_107 37 0 100meg
R_PD_108 4 0 100meg
R_PD_109 134 0 100meg
R_PD_110 N1 0 100meg
R_PD_111 3 0 100meg
R_PD_112 N90 0 100meg
R_PD_113 79 0 100meg
R_PD_114 20 0 100meg
R_PD_115 124 0 100meg
R_PD_116 N80 0 100meg
R_PD_117 N85 0 100meg
R_PD_118 7 0 100meg
R_PD_119 8 0 100meg
R_PD_120 16 0 100meg
R_PD_121 N207 0 100meg
R_PD_122 70 0 100meg
R_PD_123 99 0 100meg
R_PD_124 77 0 100meg
R_PD_125 54 0 100meg
R_PD_126 N75 0 100meg
R_PD_127 108 0 100meg
R_PD_128 35 0 100meg
R_PD_129 N390 0 100meg
R_PD_130 N91 0 100meg
R_PD_131 N418 0 100meg
R_PD_132 112 0 100meg
R_PD_133 86 0 100meg
R_PD_134 N121 0 100meg
R_PD_135 17 0 100meg
R_PD_136 114 0 100meg
R_PD_137 28 0 100meg
R_PD_138 120 0 100meg
R_PD_139 34 0 100meg
R_PD_140 36 0 100meg
R_PD_141 N195 0 100meg
R_PD_142 N768 0 100meg
R_PD_143 118 0 100meg
R_PD_144 N89 0 100meg
R_PD_145 N422 0 100meg
R_PD_146 33 0 100meg
R_PD_147 N447 0 100meg
R_PD_148 98 0 100meg
R_PD_149 N135 0 100meg
R_PD_150 N153 0 100meg
R_PD_151 N419 0 100meg
R_PD_152 53 0 100meg
R_PD_153 59 0 100meg
R_PD_154 94 0 100meg
R_PD_155 113 0 100meg
R_PD_156 N106 0 100meg
R_PD_157 47 0 100meg
R_PD_158 N268 0 100meg
R_PD_159 N267 0 100meg
R_PD_160 128 0 100meg
R_PD_161 63 0 100meg
R_PD_162 81 0 100meg
R_PD_163 42 0 100meg
R_PD_164 N149 0 100meg
R_PD_165 N86 0 100meg
R_PD_166 88 0 100meg
R_PD_167 N879 0 100meg
R_PD_168 125 0 100meg
R_PD_169 93 0 100meg
R_PD_170 N260 0 100meg
R_PD_171 N850 0 100meg
R_PD_172 N17 0 100meg
R_PD_173 92 0 100meg
R_PD_174 N68 0 100meg
R_PD_175 22 0 100meg
R_PD_176 N183 0 100meg
R_PD_177 123 0 100meg
R_PD_178 25 0 100meg
R_PD_179 N74 0 100meg
R_PD_180 80 0 100meg
R_PD_181 44 0 100meg
R_PD_182 45 0 100meg
R_PD_183 71 0 100meg
R_PD_184 N73 0 100meg
R_PD_185 32 0 100meg
R_PD_186 41 0 100meg
R_PD_187 N165 0 100meg
R_PD_188 N448 0 100meg
R_PD_189 130 0 100meg
R_PD_190 14 0 100meg
R_PD_191 104 0 100meg
R_PD_192 N8 0 100meg
R_PD_193 N51 0 100meg
R_PD_194 49 0 100meg
R_PD_195 N101 0 100meg
R_PD_196 N26 0 100meg
R_PD_197 19 0 100meg
R_PD_198 62 0 100meg
R_PD_199 122 0 100meg
R_PD_200 84 0 100meg
R_PD_201 111 0 100meg
R_PD_202 N880 0 100meg
R_PD_203 31 0 100meg
R_PD_204 N219 0 100meg
R_PD_205 N111 0 100meg
R_PD_206 N767 0 100meg
R_PD_207 129 0 100meg
R_PD_208 95 0 100meg
R_PD_209 N159 0 100meg
R_PD_210 27 0 100meg
R_PD_211 67 0 100meg
R_PD_212 78 0 100meg
R_PD_213 N878 0 100meg
R_PD_214 N177 0 100meg
R_PD_215 N865 0 100meg
R_PD_216 N261 0 100meg
R_PD_217 91 0 100meg
R_PD_218 13 0 100meg
R_PD_219 11 0 100meg
R_PD_220 133 0 100meg
R_PD_221 5 0 100meg

* Transient Simulation Directive
.TRAN 100p 10n
