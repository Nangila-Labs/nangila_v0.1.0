* Nangila SPICE Auto-Synthesized Netlist
.SUBCKT INV_X1 A Z
M1 Z A 0 0 NMOS W=0.2u L=0.05u
M2 Z A 1 1 PMOS W=0.4u L=0.05u
.ENDS

.SUBCKT NAND2_X1 A1 A2 Z
M1 Z A1 1 1 PMOS W=0.4u L=0.05u
M2 Z A2 1 1 PMOS W=0.4u L=0.05u
M3 Z A1 int 0 NMOS W=0.2u L=0.05u
M4 int A2 0 0 NMOS W=0.2u L=0.05u
.ENDS

.SUBCKT AND2_X1 A1 A2 Z
X1 A1 A2 Z_bar NAND2_X1
X2 Z_bar Z INV_X1
.ENDS

.SUBCKT NOR2_X1 A1 A2 Z
M1 int1 A1 1 1 PMOS W=0.4u L=0.05u
M2 Z A2 int1 1 PMOS W=0.4u L=0.05u
M3 Z A1 0 0 NMOS W=0.2u L=0.05u
M4 Z A2 0 0 NMOS W=0.2u L=0.05u
.ENDS

.SUBCKT OR2_X1 A1 A2 Z
X1 A1 A2 Z_bar NOR2_X1
X2 Z_bar Z INV_X1
.ENDS

.SUBCKT XOR2_X1 A1 A2 Z
X1 A1 A2 int1 AND2_X1
X2 A1 A2 int2 NOR2_X1
X3 int1 int2 int3 NOR2_X1
X4 int3 Z INV_X1
.ENDS

.SUBCKT XNOR2_X1 A B Z
X1 A B Z_int XOR2_X1
X2 Z_int Z INV_X1
.ENDS

.SUBCKT BUF_X1 A Z
X1 A Z_bar INV_X1
X2 Z_bar Z INV_X1
.ENDS

.SUBCKT OAI21_X1 A B C Z
X1 A B C Z_bar AOI21_X1
X2 Z_bar Z INV_X1
.ENDS

.SUBCKT AOI21_X1 A B C Z
M1 Z A int1 1 PMOS W=0.4u L=0.05u
M2 int1 B 1 1 PMOS W=0.4u L=0.05u
M3 Z C 1 1 PMOS W=0.4u L=0.05u
M4 Z A 0 0 NMOS W=0.2u L=0.05u
M5 Z B 0 0 NMOS W=0.2u L=0.05u
M6 Z C 0 0 NMOS W=0.2u L=0.05u
.ENDS

.SUBCKT NAND3_X1 A1 A2 A3 Z
X1 A1 A2 int1 AND2_X1
X2 int1 A3 Z NAND2_X1
.ENDS

.SUBCKT AND3_X1 A1 A2 A3 Z
X1 A1 A2 A3 Z_bar NAND3_X1
X2 Z_bar Z INV_X1
.ENDS

.SUBCKT NOR3_X1 A1 A2 A3 Z
X1 A1 A2 int1 OR2_X1
X2 int1 A3 Z NOR2_X1
.ENDS

.SUBCKT OR3_X1 A1 A2 A3 Z
X1 A1 A2 A3 Z_bar NOR3_X1
X2 Z_bar Z INV_X1
.ENDS

.SUBCKT NAND4_X1 A1 A2 A3 A4 Z
X1 A1 A2 A3 int1 AND3_X1
X2 int1 A4 Z NAND2_X1
.ENDS

.SUBCKT AND4_X1 A1 A2 A3 A4 Z
X1 A1 A2 A3 A4 Z_bar NAND4_X1
X2 Z_bar Z INV_X1
.ENDS

.SUBCKT NOR4_X1 A1 A2 A3 A4 Z
X1 A1 A2 A3 int1 OR3_X1
X2 int1 A4 Z NOR2_X1
.ENDS

.SUBCKT OR4_X1 A1 A2 A3 A4 Z
X1 A1 A2 A3 A4 Z_bar NOR4_X1
X2 Z_bar Z INV_X1
.ENDS

.SUBCKT AOI22_X1 A B C D Z
X1 A B int1 AND2_X1
X2 C D int2 AND2_X1
X3 int1 int2 Z NOR2_X1
.ENDS

.SUBCKT OAI22_X1 A B C D Z
X1 A B int1 OR2_X1
X2 C D int2 OR2_X1
X3 int1 int2 Z NAND2_X1
.ENDS

.SUBCKT AOI211_X1 A B C D Z
X1 A B int1 AND2_X1
X2 int1 C D Z NOR3_X1
.ENDS

.SUBCKT OAI211_X1 A B C D Z
X1 A B int1 OR2_X1
X2 int1 C D Z NAND3_X1
.ENDS

.SUBCKT OAI33_X1 A B C D E F Z
X1 A B C int1 OR3_X1
X2 D E F int2 OR3_X1
X3 int1 int2 Z NAND2_X1
.ENDS

.SUBCKT AOI33_X1 A B C D E F Z
X1 A B C int1 AND3_X1
X2 D E F int2 AND3_X1
X3 int1 int2 Z NOR2_X1
.ENDS

.SUBCKT MUX2_X1 A B S Z
X1 S S_bar INV_X1
X2 A S_bar int1 AND2_X1
X3 B S int2 AND2_X1
X4 int1 int2 Z OR2_X1
.ENDS

.SUBCKT DFF_X1 D C Q QN
X1 D Q_int INV_X1
X2 Q_int Q INV_X1
X3 Q_int QN INV_X1
.ENDS

.SUBCKT DFFR_X1 D C RN Q QN
X1 D Q_int INV_X1
X2 Q_int Q INV_X1
X3 Q_int QN INV_X1
.ENDS

.SUBCKT DFFS_X1 C D Q QN SN
X1 D Q_int INV_X1
X2 Q_int Q INV_X1
X3 Q_int QN INV_X1
.ENDS

.SUBCKT DFFRS_X1 C D Q QN RN SN
X1 D Q_int INV_X1
X2 Q_int Q INV_X1
X3 Q_int QN INV_X1
.ENDS

* Provide VDD power source explicitly
Vvdd 1 0 1.8

* Auto-extracted Inputs:
V_CK CK 0 1.8
V_D D 0 0.0
V_CK CK 0 1.8
V_g89 g89 0 0.0
V_g94 g94 0 1.8
V_g98 g98 0 0.0
V_g102 g102 0 1.8
V_g107 g107 0 0.0
V_g301 g301 0 1.8
V_g306 g306 0 0.0
V_g310 g310 0 1.8
V_g314 g314 0 0.0
V_g319 g319 0 1.8
V_g557 g557 0 0.0
V_g558 g558 0 1.8
V_g559 g559 0 0.0
V_g560 g560 0 1.8
V_g561 g561 0 0.0
V_g562 g562 0 1.8
V_g563 g563 0 0.0
V_g564 g564 0 1.8
V_g705 g705 0 0.0
V_g639 g639 0 1.8
V_g567 g567 0 0.0
V_g45 g45 0 1.8
V_g42 g42 0 0.0
V_g39 g39 0 1.8
V_g702 g702 0 0.0
V_g32 g32 0 1.8
V_g38 g38 0 0.0
V_g46 g46 0 1.8
V_g36 g36 0 0.0
V_g47 g47 0 1.8
V_g40 g40 0 0.0
V_g37 g37 0 1.8
V_g41 g41 0 0.0
V_g22 g22 0 1.8
V_g44 g44 0 0.0
V_g23 g23 0 1.8

* Yosys Generated Netlist:
* SPICE netlist generated by Yosys 0.62 (git sha1 7326bb7d6641500ecb285c291a54a662cb1e76cf, clang++ 17.0.0 -fPIC -O3)

.SUBCKT dff CK Q D
X0 CK D Q 1 DFF_X1
.ENDS dff

X0 g1161 1 INV_X1
X1 g89 2 INV_X1
X2 g1236 3 INV_X1
X3 g1143 g2587 INV_X1
X4 I4294 4 INV_X1
X5 g1123 g2586 INV_X1
X6 g1193 5 INV_X1
X7 g1177 6 INV_X1
X8 g1209 7 INV_X1
X9 g1222 8 INV_X1
X10 g492 9 INV_X1
X11 g679 10 INV_X1
X12 g211 11 INV_X1
X13 I2596 12 INV_X1
X14 g536 13 INV_X1
X15 g639 14 INV_X1
X16 g210 15 INV_X1
X17 g2312 16 INV_X1
X18 g45 17 INV_X1
X19 g669 18 INV_X1
X20 g1017 19 INV_X1
X21 g1011 20 INV_X1
X22 g1001 21 INV_X1
X23 I2479 g1049 INV_X1
X24 g283 22 INV_X1
X25 g1279 23 INV_X1
X26 g41 24 INV_X1
X27 g208 25 INV_X1
X28 g280 26 INV_X1
X29 g209 27 INV_X1
X30 g1076 28 INV_X1
X31 g489 29 INV_X1
X32 g486 30 INV_X1
X33 g47 g4426 INV_X1
X34 I2521 31 INV_X1
X35 g2 g1 32 XNOR2_X1
X36 g3714 g10 33 XOR2_X1
X37 32 33 34 XNOR2_X1
X38 g24 g28 35 XNOR2_X1
X39 g14 35 36 XNOR2_X1
X40 34 36 37 XNOR2_X1
X41 g3541 g18 38 XOR2_X1
X42 37 38 39 XNOR2_X1
X43 g676 39 g41 40 OAI21_X1
X44 g22 31 40 g6282 OR3_X1
X45 24 g6282 41 OR2_X1
X46 g1735 g1696 42 XOR2_X1
X47 g1692 g1703 43 XNOR2_X1
X48 42 43 44 XNOR2_X1
X49 g11 g1711 45 XOR2_X1
X50 g15 g1699 46 XNOR2_X1
X51 45 46 47 XNOR2_X1
X52 44 47 g6729 XNOR2_X1
X53 41 g6729 g6284 OR2_X1
X54 2 g102 g2584 NOR2_X1
X55 3 I4294 48 NOR2_X1
X56 g1372 g1875 49 NAND2_X1
X57 g1372 g1363 g1875 50 NAND3_X1
X58 g1375 g1372 g1363 g1875 51 NAND4_X1
X59 g208 g209 52 NAND2_X1
X60 25 51 53 NOR2_X1
X61 51 52 54 NOR2_X1
X62 g1161 g1123 g1372 55 MUX2_X1
X63 g1177 g1143 g1372 56 MUX2_X1
X64 56 55 g1875 57 MUX2_X1
X65 g1222 g1193 g1372 58 MUX2_X1
X66 g1236 g1209 g1372 59 MUX2_X1
X67 59 58 g1875 60 MUX2_X1
X68 60 57 g1363 61 MUX2_X1
X69 g208 g209 62 XOR2_X1
X70 g471 61 63 XNOR2_X1
X71 62 63 64 NOR2_X1
X72 g211 15 65 NOR2_X1
X73 g208 27 51 66 OR3_X1
X74 66 67 INV_X1
X75 62 66 68 AND2_X1
X76 g471 66 69 NAND2_X1
X77 69 68 g471 70 OAI21_X1
X78 70 63 62 71 OAI21_X1
X79 11 15 72 NOR2_X1
X80 71 72 73 AND2_X1
X81 64 65 71 72 74 AOI22_X1
X82 g211 15 75 NAND2_X1
X83 51 52 74 75 76 AOI211_X1
X84 54 74 77 OR2_X1
X85 54 65 78 NAND2_X1
X86 77 78 64 76 11 79 OAI221_X1
X87 48 79 I4294 80 AOI21_X1
X88 80 g6806 INV_X1
X89 g1363 49 81 XOR2_X1
X90 g211 g210 g471 82 NOR3_X1
X91 54 68 82 83 AOI21_X1
X92 g211 g210 g471 68 84 NOR4_X1
X93 I4294 83 85 NAND2_X1
X94 84 85 86 OR2_X1
X95 1 I4294 81 86 g5705 OAI22_X1
X96 I3251 g610 g613 87 AND3_X1
X97 g616 87 88 AND2_X1
X98 g619 88 89 AND2_X1
X99 g622 89 90 AND2_X1
X100 g628 g625 90 91 AND3_X1
X101 g631 91 92 AND2_X1
X102 g1270 92 93 AND2_X1
X103 g1257 93 94 AND2_X1
X104 g1257 g1263 95 AND2_X1
X105 93 95 96 NAND2_X1
X106 g1270 95 97 NAND2_X1
X107 g1270 g1267 92 95 98 AND4_X1
X108 g1276 98 99 NAND2_X1
X109 g639 23 99 100 OAI21_X1
X110 g1270 92 101 NOR2_X1
X111 93 100 101 g6592 NOR3_X1
X112 g15 41 g6372 OR2_X1
X113 g1519 g1381 g1348 102 NAND3_X1
X114 g1519 g1384 g1381 g1348 103 AND4_X1
X115 g280 103 104 AND2_X1
X116 g281 104 105 NAND2_X1
X117 g281 26 103 106 NAND3_X1
X118 g281 g280 107 XOR2_X1
X119 106 107 108 NAND2_X1
X120 g282 g478 g283 109 NOR3_X1
X121 109 110 INV_X1
X122 106 107 109 111 NAND3_X1
X123 105 111 112 AND2_X1
X124 g1384 102 113 XOR2_X1
X125 112 113 114 NAND2_X1
X126 108 109 115 NAND2_X1
X127 I3672 114 115 116 NAND3_X1
X128 116 6 I3672 g5717 OAI21_X1
X129 g210 70 g211 117 OAI21_X1
X130 117 118 INV_X1
X131 77 118 119 NAND2_X1
X132 76 84 120 NOR2_X1
X133 76 84 118 77 121 AOI211_X1
X134 119 120 122 NAND2_X1
X135 8 121 I4294 123 MUX2_X1
X136 123 g6803 INV_X1
X137 I3672 8 124 NOR2_X1
X138 g282 22 125 NAND2_X1
X139 g1143 g1123 g1519 126 MUX2_X1
X140 g1177 g1161 g1519 127 MUX2_X1
X141 127 126 g1381 128 MUX2_X1
X142 g1209 g1193 g1519 129 MUX2_X1
X143 g1236 g1222 g1519 130 MUX2_X1
X144 130 129 g1381 131 MUX2_X1
X145 131 128 g1348 132 MUX2_X1
X146 g478 132 133 OR2_X1
X147 g478 132 134 XNOR2_X1
X148 107 132 g478 135 AOI21_X1
X149 107 125 134 136 NOR3_X1
X150 107 125 134 137 OR3_X1
X151 g478 106 138 XOR2_X1
X152 107 138 139 NAND2_X1
X153 133 135 138 107 140 AOI22_X1
X154 139 134 107 141 OAI21_X1
X155 g282 g283 142 AND2_X1
X156 g282 g283 143 NAND2_X1
X157 137 140 143 144 OAI21_X1
X158 g282 g283 139 145 OAI21_X1
X159 145 144 105 146 AOI21_X1
X160 g282 22 147 NOR2_X1
X161 136 147 142 141 148 AOI211_X1
X162 115 148 105 149 OAI21_X1
X163 105 125 133 135 150 AOI211_X1
X164 146 149 151 OR2_X1
X165 124 151 I3672 152 AOI21_X1
X166 152 g6809 INV_X1
X167 g1696 41 g6362 OR2_X1
X168 I3672 112 153 NAND2_X1
X169 I3672 105 110 154 NAND3_X1
X170 g1519 g1381 155 XNOR2_X1
X171 I3672 g2587 154 155 g5708 OAI22_X1
X172 I2596 g567 g3234 156 OAI21_X1
X173 156 g3234 g567 g4122 AOI21_X1
X174 g208 51 157 XNOR2_X1
X175 86 157 158 NOR2_X1
X176 158 5 4 g5590 AOI21_X1
X177 g209 53 84 159 NOR3_X1
X178 I4294 7 85 159 g5720 OAI22_X1
X179 g1699 41 g6364 OR2_X1
X180 g567 g3235 g3234 160 AND3_X1
X181 g3235 g3234 g567 161 AOI21_X1
X182 12 160 161 g4424 NOR3_X1
X183 g1372 g1875 162 XNOR2_X1
X184 g2587 I4294 86 162 g5702 OAI22_X1
X185 g11 41 g6370 OR2_X1
X186 g639 I3251 g610 163 OAI21_X1
X187 163 g610 I3251 g4124 AOI21_X1
X188 17 I2479 g4659 NOR2_X1
X189 g1692 41 g6360 OR2_X1
X190 100 99 23 g6596 AOI21_X1
X191 g639 g622 89 164 OAI21_X1
X192 90 164 g5147 NOR2_X1
X193 g3236 160 165 AND2_X1
X194 g3237 165 166 AND2_X1
X195 I2596 g3238 166 167 OAI21_X1
X196 167 166 g3238 g5148 AOI21_X1
X197 I4294 g2586 g1875 86 g5584 OAI22_X1
X198 3 I3672 168 NOR2_X1
X199 150 144 105 169 AOI21_X1
X200 169 149 22 170 OAI21_X1
X201 168 170 I3672 171 AOI21_X1
X202 171 g6812 INV_X1
X203 g639 g619 88 172 OAI21_X1
X204 89 172 g4858 NOR2_X1
X205 26 103 173 XNOR2_X1
X206 I3672 g1193 154 173 174 OAI22_X1
X207 174 g5593 INV_X1
X208 g281 104 109 26 175 AOI211_X1
X209 I3672 7 153 175 g5723 OAI22_X1
X210 I2596 g3237 165 176 OAI21_X1
X211 166 176 g4857 NOR2_X1
X212 I2596 g3236 160 177 OAI21_X1
X213 165 177 g4658 NOR2_X1
X214 I4294 6 178 NOR2_X1
X215 g1375 50 179 XOR2_X1
X216 4 84 179 83 180 AOI211_X1
X217 178 180 g5711 OR2_X1
X218 17 I3102 g4425 NOR2_X1
X219 14 I3251 g4123 NOR2_X1
X220 g1348 g1381 g1519 181 AOI21_X1
X221 I3672 102 105 110 182 NAND4_X1
X222 1 I3672 181 182 g5714 OAI22_X1
X223 g3238 g3239 166 183 AND3_X1
X224 g3239 166 g3238 184 AOI21_X1
X225 12 183 184 g5329 NOR3_X1
X226 g639 g616 87 185 OAI21_X1
X227 88 185 g4657 NOR2_X1
X228 g1703 41 g6366 OR2_X1
X229 g1735 41 g6374 OR2_X1
X230 g3241 183 g3240 186 AOI21_X1
X231 g3240 g3241 183 187 AND3_X1
X232 12 186 187 g5580 NOR3_X1
X233 g1711 41 g6368 OR2_X1
X234 g1263 94 188 NOR2_X1
X235 100 188 93 95 g6594 AOI211_X1
X236 I3672 g2586 g1519 154 g5587 OAI22_X1
X237 g628 g625 90 189 AOI21_X1
X238 14 91 189 g5489 NOR3_X1
X239 g639 g625 90 190 OAI21_X1
X240 190 90 g625 g5328 AOI21_X1
X241 g1257 93 191 NOR2_X1
X242 94 100 191 g6593 NOR3_X1
X243 I2596 g3240 183 192 OAI21_X1
X244 192 183 g3240 g5490 AOI21_X1
X245 g639 g631 91 193 OAI21_X1
X246 92 193 g5581 NOR2_X1
X247 g528 g254 194 XNOR2_X1
X248 g516 g236 195 XNOR2_X1
X249 g520 g242 196 XOR2_X1
X250 g508 g224 197 XOR2_X1
X251 g532 g260 198 XNOR2_X1
X252 g500 g212 199 XOR2_X1
X253 g504 g218 200 XOR2_X1
X254 g524 g248 201 XOR2_X1
X255 g512 g230 202 XOR2_X1
X256 197 200 201 203 NOR3_X1
X257 194 195 198 203 204 NAND4_X1
X258 196 199 202 204 205 NOR4_X1
X259 13 205 206 NAND2_X1
X260 g541 206 207 NOR2_X1
X261 g461 g430 207 g4841 MUX2_X1
X262 g548 79 205 g6825 MUX2_X1
X263 g702 g699 208 NAND2_X1
X264 g1030 g1101 g1094 209 NAND3_X1
X265 g1088 209 210 NOR2_X1
X266 g1017 20 210 211 NAND3_X1
X267 g41 40 208 211 212 OR4_X1
X268 g1177 g1335 212 g6512 MUX2_X1
X269 24 I3102 208 213 NOR3_X1
X270 g662 213 214 NAND2_X1
X271 40 214 215 NOR2_X1
X272 g1088 g1101 g1094 216 OR3_X1
X273 40 214 216 217 OR3_X1
X274 g1076 217 218 NOR2_X1
X275 218 219 INV_X1
X276 g1101 g1030 g1088 220 OAI21_X1
X277 213 g662 I2479 221 OAI21_X1
X278 221 222 INV_X1
X279 g1088 g1006 209 223 NOR3_X1
X280 g1017 g1011 21 223 224 NAND4_X1
X281 16 221 224 225 NOR3_X1
X282 19 20 221 226 NOR3_X1
X283 g1006 210 227 AND2_X1
X284 g1088 g1101 g1094 228 NAND3_X1
X285 g1088 g678 g1101 g1094 229 NAND4_X1
X286 10 g680 221 229 230 NOR4_X1
X287 223 226 231 NAND2_X1
X288 g679 g678 228 232 NOR3_X1
X289 g679 g678 228 233 OR3_X1
X290 221 233 211 234 AOI21_X1
X291 g1094 215 220 235 AND3_X1
X292 g680 221 228 236 NOR3_X1
X293 g678 236 237 NAND2_X1
X294 g1006 210 226 238 NAND3_X1
X295 21 231 239 NOR2_X1
X296 234 226 210 240 AOI21_X1
X297 217 237 240 241 NAND3_X1
X298 235 241 242 OR2_X1
X299 28 217 243 NOR2_X1
X300 28 217 244 OR2_X1
X301 g2312 238 245 NOR2_X1
X302 16 238 246 NOR2_X1
X303 g441 245 246 g422 247 AOI22_X1
X304 247 248 INV_X1
X305 16 g1001 231 249 NOR3_X1
X306 10 237 250 NOR2_X1
X307 248 249 g520 250 g559 251 AOI221_X1
X308 g5720 218 243 g5723 235 g1209 252 AOI222_X1
X309 242 251 252 g6601 NAND3_X1
X310 g41 40 208 224 253 NOR4_X1
X311 g2312 253 254 NAND2_X1
X312 g1236 g528 254 g6504 MUX2_X1
X313 g1123 I4294 212 g6509 MUX2_X1
X314 g449 g453 207 g4844 MUX2_X1
X315 g430 246 249 g528 g557 250 255 AOI222_X1
X316 g1236 235 245 g434 256 AOI22_X1
X317 242 255 256 257 AND3_X1
X318 257 244 171 80 219 g6854 OAI221_X1
X319 g1279 g1276 258 XOR2_X1
X320 g1123 g1257 259 NAND2_X1
X321 g1263 259 1 g1257 260 OAI211_X1
X322 g1222 g1193 g1257 261 MUX2_X1
X323 g1270 260 261 g1263 262 OAI211_X1
X324 g1236 g1257 263 NOR2_X1
X325 6 g1257 264 NOR2_X1
X326 g1263 263 7 g1257 265 AOI211_X1
X327 265 264 g1263 g1143 95 266 AOI221_X1
X328 g1270 266 267 NOR2_X1
X329 258 267 268 NOR2_X1
X330 23 g1276 97 269 NOR3_X1
X331 262 268 269 g1267 g6407 AOI22_X1
X332 g1161 g1094 215 220 270 NAND4_X1
X333 13 g2312 221 224 271 NOR4_X1
X334 271 225 g508 g551 239 272 AOI221_X1
X335 211 221 273 NOR2_X1
X336 g562 230 273 g1332 274 AOI22_X1
X337 g453 16 226 227 275 NAND4_X1
X338 g410 g2312 226 227 276 NAND4_X1
X339 272 274 275 276 277 AND4_X1
X340 g5705 218 243 g5714 278 AOI22_X1
X341 242 270 277 278 g6599 NAND4_X1
X342 16 253 279 AND2_X1
X343 g1119 106 280 NAND2_X1
X344 205 280 g1119 67 281 OAI211_X1
X345 279 281 g536 282 AOI21_X1
X346 282 279 1 g6506 AOI21_X1
X347 g410 g406 207 g4851 MUX2_X1
X348 g434 g437 207 g4848 MUX2_X1
X349 g1267 96 283 XNOR2_X1
X350 100 283 g6591 OR2_X1
X351 g5590 218 243 g5593 284 AOI22_X1
X352 g1193 235 246 g418 285 AOI22_X1
X353 g445 245 249 g516 g560 250 286 AOI222_X1
X354 242 286 287 AND2_X1
X355 284 285 287 g6600 NAND3_X1
X356 g554 170 205 g6827 MUX2_X1
X357 g445 g449 207 g4845 MUX2_X1
X358 g41 g22 39 288 NOR3_X1
X359 g672 288 g5491 OR2_X1
X360 g1193 g516 254 g6501 MUX2_X1
X361 g441 g445 207 g4846 MUX2_X1
X362 g1161 g508 254 g6499 MUX2_X1
X363 g422 g418 207 g4854 MUX2_X1
X364 g406 g402 207 g4850 MUX2_X1
X365 g426 g422 207 g4855 MUX2_X1
X366 g1119 54 289 NOR2_X1
X367 206 289 g1119 105 290 AOI211_X1
X368 g541 279 290 291 NOR3_X1
X369 291 279 6 g6505 AOI21_X1
X370 g418 g414 207 g4853 MUX2_X1
X371 g457 g461 207 g4842 MUX2_X1
X372 g430 g426 207 g4856 MUX2_X1
X373 g1276 98 292 XOR2_X1
X374 100 292 g6595 OR2_X1
X375 g1143 g504 254 g6498 MUX2_X1
X376 g545 205 293 NOR2_X1
X377 293 205 121 g6824 AOI21_X1
X378 g1119 g1143 279 g6507 MUX2_X1
X379 g1209 g520 254 g6502 MUX2_X1
X380 g471 g478 g1119 294 MUX2_X1
X381 g402 294 207 g4849 MUX2_X1
X382 g1143 I3672 212 g6510 MUX2_X1
X383 g532 g1123 279 g6508 MUX2_X1
X384 g5702 218 243 g5708 295 AOI22_X1
X385 g672 g680 222 232 296 AND4_X1
X386 g680 221 233 297 NOR3_X1
X387 g548 239 249 g504 297 g492 298 AOI222_X1
X388 10 g678 236 299 NAND3_X1
X389 g489 299 300 NOR2_X1
X390 300 273 I3672 301 AOI21_X1
X391 g406 246 250 g563 g457 245 302 AOI222_X1
X392 g2312 g1001 231 303 NOR3_X1
X393 296 303 g1119 304 AOI21_X1
X394 298 301 302 304 305 AND4_X1
X395 g1143 235 306 NAND2_X1
X396 242 295 305 306 g6598 NAND4_X1
X397 g437 g441 207 g4847 MUX2_X1
X398 g1177 g512 254 g6500 MUX2_X1
X399 g5584 218 243 g5587 307 AOI22_X1
X400 g669 g680 222 232 308 AND4_X1
X401 g545 239 297 g496 249 g500 309 AOI222_X1
X402 g486 299 310 NOR2_X1
X403 310 273 I4294 311 AOI21_X1
X404 g461 245 246 g402 250 g564 312 AOI222_X1
X405 308 303 g532 313 AOI21_X1
X406 309 311 312 313 314 AND4_X1
X407 g1123 235 315 NAND2_X1
X408 242 307 314 315 g6597 NAND4_X1
X409 g1161 g1332 212 g6511 MUX2_X1
X410 9 140 143 g6744 OAI21_X1
X411 g453 g457 207 g4843 MUX2_X1
X412 g1123 g500 254 g6497 MUX2_X1
X413 g414 g410 207 g4852 MUX2_X1
X414 g496 73 g6745 OR2_X1
X415 g37 g38 316 XNOR2_X1
X416 g40 g39 317 XNOR2_X1
X417 316 317 318 XNOR2_X1
X418 g36 g32 319 XNOR2_X1
X419 318 319 320 XNOR2_X1
X420 39 320 g5019 XNOR2_X1
X421 18 g22 g5019 g5582 OAI21_X1
X422 g551 151 205 g6826 MUX2_X1
X423 g613 g610 I3251 321 AOI21_X1
X424 g639 87 321 g4423 OAI21_X1
X425 g554 239 273 g1335 322 AOI22_X1
X426 g449 245 250 g561 246 g414 323 AOI222_X1
X427 322 323 324 NAND2_X1
X428 324 303 g541 g512 249 325 AOI221_X1
X429 g1177 235 243 g5717 g5711 218 326 AOI222_X1
X430 242 325 326 g6602 NAND3_X1
X431 g1222 g524 254 g6503 MUX2_X1
X432 I2596 g567 g4121 NAND2_X1
X433 g426 246 250 g558 249 g524 327 AOI222_X1
X434 327 241 235 328 OAI21_X1
X435 328 245 g437 g1222 235 329 AOI221_X1
X436 329 244 152 123 219 g6853 OAI221_X1
X437 79 122 g6800 NAND2_X1
X438 151 170 g6801 NAND2_X1
X439 g492 29 30 g496 g4809 AOI22_X1
X440 g1699 g6720 BUF_X1
X441 g1703 g6727 BUF_X1
X442 g1735 g6724 BUF_X1
X443 g1692 g6725 BUF_X1
X444 g11 g6722 BUF_X1
X445 g1696 g6726 BUF_X1
X446 g1711 g6721 BUF_X1
X447 g15 g6723 BUF_X1
X448 CK g678 g2 dff
X449 CK g24 g6726 dff
X450 CK g504 g6498 dff
X451 CK g1292 g42 dff
X452 CK g541 g6505 dff
X453 CK g1222 g24 dff
X454 CK g516 g6501 dff
X455 CK g1119 g6507 dff
X456 CK g536 g6506 dff
X457 CK g1011 g24 dff
X458 CK g545 g6824 dff
X459 CK g254 g3240 dff
X460 CK g2 g6721 dff
X461 CK g628 g5489 dff
X462 CK g679 g3714 dff
X463 CK g28 g6727 dff
X464 CK g1088 g38 dff
X465 CK g283 g6812 dff
X466 CK g613 g4423 dff
X467 CK g10 g6723 dff
X468 CK g14 g6724 dff
X469 CK g680 g10 dff
X470 CK g672 g5491 dff
X471 CK g1289 g45 dff
X472 CK g1384 g5717 dff
X473 CK g492 g6744 dff
X474 CK I2596 g1289 dff
X475 CK g676 g5019 dff
X476 CK I3251 g4123 dff
X477 CK g3236 g4658 dff
X478 CK g280 g5593 dff
X479 CK g1288 g42 dff
X480 CK g610 g4124 dff
X481 CK g209 g5720 dff
X482 CK I2521 g702 dff
X483 CK g478 g1292 dff
X484 CK g622 g5147 dff
X485 CK g1279 g6596 dff
X486 CK g489 g2587 dff
X487 CK g616 g4657 dff
X488 CK g218 g3234 dff
X489 CK g242 g3238 dff
X490 CK g1270 g6592 dff
X491 CK g668 g6800 dff
X492 CK g422 g4854 dff
X493 CK g210 g6803 dff
X494 CK g230 g3236 dff
X495 CK g1692 g6601 dff
X496 CK g1875 g5584 dff
X497 CK I3102 g4425 dff
X498 CK g1348 g5714 dff
X499 CK g3239 g5329 dff
X500 CK g508 g6499 dff
X501 CK g548 g6825 dff
X502 CK g406 g4850 dff
X503 CK g236 g3237 dff
X504 CK g500 g6497 dff
X505 CK g1372 g5702 dff
X506 CK I4294 g6509 dff
X507 CK g666 g46 dff
X508 CK g524 g6503 dff
X509 CK g260 g3241 dff
X510 CK g1711 g6598 dff
X511 CK g1735 g6600 dff
X512 CK g2312 g1 dff
X513 CK g1257 g6593 dff
X514 CK g3234 g4122 dff
X515 CK g485 g6801 dff
X516 CK g699 g4426 dff
X517 CK g414 g4852 dff
X518 CK g434 g4848 dff
X519 CK I2479 g4659 dff
X520 CK g554 g6827 dff
X521 CK g1161 g3714 dff
X522 CK g1381 g5708 dff
X523 CK g512 g6500 dff
X524 CK g532 g6508 dff
X525 CK g1193 g14 dff
X526 CK g1143 g2 dff
X527 CK g1 g6720 dff
X528 CK g496 g6745 dff
X529 CK g3541 g6729 dff
X530 CK g1276 g6595 dff
X531 CK g551 g6826 dff
X532 CK g1006 g18 dff
X533 CK g11 g6599 dff
X534 CK g3237 g4857 dff
X535 CK g1375 g5711 dff
X536 CK g3238 g5148 dff
X537 CK g1017 g28 dff
X538 CK g619 g4858 dff
X539 CK g208 g5590 dff
X540 CK g248 g3239 dff
X541 CK g1209 g18 dff
X542 CK g625 g5328 dff
X543 CK g1001 g14 dff
X544 CK g437 g4847 dff
X545 CK g1519 g5587 dff
X546 CK g1699 g6597 dff
X547 CK g224 g3235 dff
X548 CK g1030 g32 dff
X549 CK g43 g6407 dff
X550 CK g461 g4841 dff
X551 CK g282 g6809 dff
X552 CK g1236 g28 dff
X553 CK g1363 g5705 dff
X554 CK g449 g4844 dff
X555 CK g528 g6504 dff
X556 CK g426 g4855 dff
X557 CK g3235 g4424 dff
X558 CK g669 g5582 dff
X559 CK g18 g6725 dff
X560 CK g520 g6502 dff
X561 CK g281 g5723 dff
X562 CK g15 g6602 dff
X563 CK g631 g5581 dff
X564 CK g1177 g10 dff
X565 CK g457 g4842 dff
X566 CK g486 g2586 dff
X567 CK g471 g1291 dff
X568 CK g418 g4853 dff
X569 CK g402 g4849 dff
X570 CK g1335 g6512 dff
X571 CK g212 g567 dff
X572 CK g410 g4851 dff
X573 CK g430 g4856 dff
X574 CK g1703 g6854 dff
X575 CK g662 g1049 dff
X576 CK g453 g4843 dff
X577 CK I3672 g6510 dff
X578 CK g1267 g6591 dff
X579 CK g441 g4846 dff
X580 CK g1291 g1288 dff
X581 CK g211 g6806 dff
X582 CK g1263 g6594 dff
X583 CK g3241 g5580 dff
X584 CK g1094 g39 dff
X585 CK g1696 g6853 dff
X586 CK g1101 g40 dff
X587 CK g3240 g5490 dff
X588 CK g1332 g6511 dff
X589 CK g1123 g1 dff
X590 CK g445 g4845 dff
X591 CK g3714 g6722 dff
X592 CK g1076 g37 dff
V0 g4809 g2433 DC 0
V1 g1123 g2436 DC 0
V2 g1875 g1998 DC 0
V3 g1001 g2449 DC 0
V4 g2312 g2457 DC 0
V5 g1143 g2460 DC 0
V6 g1161 g2096 DC 0
V7 g1519 g1988 DC 0
V8 g1143 g2097 DC 0
V9 g1006 g2473 DC 0
V10 g2312 g2481 DC 0
V11 g1161 g2484 DC 0
V12 g1875 g1979 DC 0
V13 g1375 g207 DC 0
V14 I4294 g197 DC 0
V15 g1011 g2497 DC 0
V16 g1692 g25 DC 0
V17 g1177 g2505 DC 0
V18 g1519 g1969 DC 0
V19 g1875 g1960 DC 0
V20 g1017 g2518 DC 0
V21 g1193 g2524 DC 0
V22 g1177 g2102 DC 0
V23 g1161 g2103 DC 0
V24 g1519 g1950 DC 0
V25 g1519 g1947 DC 0
V26 g1030 g2544 DC 0
V27 g1123 g2550 DC 0
V28 g1209 g2554 DC 0
V29 g1143 g2574 DC 0
V30 g1222 g2575 DC 0
V31 g1161 g2576 DC 0
V32 g1236 g2580 DC 0
V33 g1177 g2581 DC 0
V34 g1236 g2588 DC 0
V35 g1222 g2591 DC 0
V36 g1236 g2594 DC 0
V37 g1123 g2599 DC 0
V38 g1143 g2604 DC 0
V39 g1257 g1937 DC 0
V40 g1161 g2609 DC 0
V41 g1270 g2612 DC 0
V42 g1519 g1931 DC 0
V43 g4426 g2618 DC 0
V44 g1177 g2619 DC 0
V45 g1270 g2622 DC 0
V46 g1875 g1928 DC 0
V47 g1875 g1925 DC 0
V48 g1193 g2631 DC 0
V49 g1270 g2634 DC 0
V50 g1123 g2086 DC 0
V51 g1209 g2644 DC 0
V52 g1270 g2647 DC 0
V53 g1270 g2650 DC 0
V54 g1519 g1914 DC 0
V55 g1875 g1911 DC 0
V56 I2479 g266 DC 0
V57 g1222 g2660 DC 0
V58 g1193 g2108 DC 0
V59 g1177 g2109 DC 0
V60 g1267 g1902 DC 0
V61 g4124 g2670 DC 0
V62 g1236 g2672 DC 0
V63 g1270 g2675 DC 0
V64 g1735 g19 DC 0
V65 g1257 g1899 DC 0
V66 g1519 g1894 DC 0
V67 g567 g2686 DC 0
V68 g1875 g1891 DC 0
V69 g1123 g2688 DC 0
V70 I3672 g269 DC 0
V71 g1263 g1884 DC 0
V72 g1123 g2701 DC 0
V73 g3234 g2705 DC 0
V74 g1143 g2706 DC 0
V75 g1270 g2709 DC 0
V76 g1363 g206 DC 0
V77 g1143 g2722 DC 0
V78 g3235 g2726 DC 0
V79 g1257 g1858 DC 0
V80 g1257 g1854 DC 0
V81 g1161 g2734 DC 0
V82 g2587 g1852 DC 0
V83 g3236 g2739 DC 0
V84 g1270 g2740 DC 0
V85 g1263 g1849 DC 0
V86 I3102 g2744 DC 0
V87 g1177 g2748 DC 0
V88 g2586 g1848 DC 0
V89 g3237 g2753 DC 0
V90 g1143 g1846 DC 0
V91 I3102 g2755 DC 0
V92 I3102 g2756 DC 0
V93 g1519 g276 DC 0
V94 g1193 g2760 DC 0
V95 g3238 g2765 DC 0
V96 g1123 g1841 DC 0
V97 I3102 g2767 DC 0
V98 I3102 g2768 DC 0
V99 g1381 g277 DC 0
V100 g1209 g2772 DC 0
V101 g3239 g2777 DC 0
V102 I3102 g2778 DC 0
V103 I3102 g2779 DC 0
V104 g1348 g278 DC 0
V105 g1222 g2783 DC 0
V106 g1236 g1837 DC 0
V107 g3240 g2788 DC 0
V108 I3102 g2789 DC 0
V109 g1384 g279 DC 0
V110 I3102 g2790 DC 0
V111 I3102 g2792 DC 0
V112 g1236 g2796 DC 0
V113 g1222 g1836 DC 0
V114 g3241 g2801 DC 0
V115 I3102 g2802 DC 0
V116 I3102 g2803 DC 0
V117 I3102 g2805 DC 0
V118 I3102 g2806 DC 0
V119 g1123 g2809 DC 0
V120 g1209 g1835 DC 0
V121 g43 g2814 DC 0
V122 I3102 g2817 DC 0
V123 I3102 g2818 DC 0
V124 I3102 g2819 DC 0
V125 I3102 g2820 DC 0
V126 g1143 g2822 DC 0
V127 g1143 g1834 DC 0
V128 I3102 g2827 DC 0
V129 I3102 g2828 DC 0
V130 I3102 g2829 DC 0
V131 I3102 g2830 DC 0
V132 I3102 g2835 DC 0
V133 I3102 g2836 DC 0
V134 I3102 g2837 DC 0
V135 I3102 g2838 DC 0
V136 I3102 g2839 DC 0
V137 I3102 g2840 DC 0
V138 I3102 g2841 DC 0
V139 I3102 g2845 DC 0
V140 g1193 g1833 DC 0
V141 g4122 g2859 DC 0
V142 g4123 g2861 DC 0
V143 g1123 g1832 DC 0
V144 I3102 g2864 DC 0
V145 I3102 g2866 DC 0
V146 I3102 g2867 DC 0
V147 g1049 g1831 DC 0
V148 I3102 g2871 DC 0
V149 I3102 g2872 DC 0
V150 g564 g1830 DC 0
V151 I3102 g2875 DC 0
V152 I3102 g2876 DC 0
V153 I3102 g2883 DC 0
V154 I3102 g2884 DC 0
V155 I3102 g2885 DC 0
V156 I3102 g2886 DC 0
V157 g1236 g1825 DC 0
V158 I3102 g2888 DC 0
V159 I3102 g2889 DC 0
V160 g1123 g1824 DC 0
V161 g1123 g1823 DC 0
V162 I3102 g2892 DC 0
V163 I3102 g2893 DC 0
V164 g1143 g1821 DC 0
V165 g1143 g1820 DC 0
V166 g1696 g29 DC 0
V167 g1123 g1819 DC 0
V168 g1161 g1814 DC 0
V169 I3102 g2904 DC 0
V170 I3102 g2905 DC 0
V171 g1161 g1813 DC 0
V172 g1143 g1812 DC 0
V173 I3102 g2912 DC 0
V174 g1177 g1811 DC 0
V175 g1177 g1807 DC 0
V176 g1161 g1806 DC 0
V177 g1236 g1805 DC 0
V178 g2584 g1802 DC 0
V179 g1193 g1792 DC 0
V180 g1193 g1791 DC 0
V181 g1177 g1790 DC 0
V182 g1123 g1789 DC 0
V183 g1332 g293 DC 0
V184 I2596 g1788 DC 0
V185 g1209 g1787 DC 0
V186 g1209 g1783 DC 0
V187 g1193 g1782 DC 0
V188 g705 g2945 DC 0
V189 g485 g2967 DC 0
V190 g1143 g1781 DC 0
V191 g1335 g297 DC 0
V192 g668 g2974 DC 0
V193 g3239 g2975 DC 0
V194 g1372 g205 DC 0
V195 g1222 g1774 DC 0
V196 g1161 g2998 DC 0
V197 g1699 g3 DC 0
V198 g3240 g3001 DC 0
V199 g1177 g3016 DC 0
V200 g1222 g1773 DC 0
V201 g3241 g3022 DC 0
V202 g1193 g3031 DC 0
V203 g1209 g1772 DC 0
V204 g1161 g1771 DC 0
V205 g567 g3040 DC 0
V206 g1209 g3043 DC 0
V207 g3234 g3052 DC 0
V208 g1222 g3054 DC 0
V209 g1236 g1762 DC 0
V210 g1236 g1761 DC 0
V211 g3235 g3063 DC 0
V212 g1236 g3064 DC 0
V213 g1222 g1760 DC 0
V214 g1177 g1759 DC 0
V215 g3236 g3073 DC 0
V216 g1236 g1748 DC 0
V217 g3237 g3082 DC 0
V218 g1193 g1747 DC 0
V219 g1209 g1739 DC 0
V220 g3238 g3093 DC 0
V221 g1209 g2117 DC 0
V222 g1161 g3104 DC 0
V223 g1222 g1733 DC 0
V224 g1236 g1732 DC 0
V225 g1177 g3118 DC 0
V226 g15 g1726 DC 0
V227 g1193 g3128 DC 0
V228 g1209 g3136 DC 0
V229 g1222 g3150 DC 0
V230 g1123 g3158 DC 0
V231 g1236 g3162 DC 0
V232 g1143 g3173 DC 0
V233 g1123 g3177 DC 0
V234 g1161 g3183 DC 0
V235 g1143 g3187 DC 0
V236 g1177 g3192 DC 0
V237 g1161 g3196 DC 0
V238 g1193 g3200 DC 0
V239 g1177 g3204 DC 0
V240 g1209 g3209 DC 0
V241 g1193 g3212 DC 0
V242 g1222 g3216 DC 0
V243 g1209 g3219 DC 0
V244 g705 g3222 DC 0
V245 g567 g3224 DC 0
V246 g3234 g3225 DC 0
V247 g3235 g3226 DC 0
V248 g3236 g3227 DC 0
V249 g3237 g3228 DC 0
V250 g3238 g3229 DC 0
V251 g3239 g3230 DC 0
V252 g3240 g3231 DC 0
V253 g3241 g3232 DC 0
V254 g567 g3233 DC 0
V255 g14 g3242 DC 0
V256 g18 g3247 DC 0
V257 g24 g3259 DC 0
V258 g28 g3263 DC 0
V259 g32 g3267 DC 0
V260 g36 g3271 DC 0
V261 I4294 g3284 DC 0
V262 I4294 g3289 DC 0
V263 I3672 g3291 DC 0
V264 g43 g1724 DC 0
V265 I4294 g3297 DC 0
V266 I3672 g3299 DC 0
V267 g1703 g33 DC 0
V268 I4294 g3306 DC 0
V269 I3672 g3308 DC 0
V270 g11 g1721 DC 0
V271 I4294 g3320 DC 0
V272 I3672 g3322 DC 0
V273 I4294 g3331 DC 0
V274 I3672 g3332 DC 0
V275 I4294 g3342 DC 0
V276 I3672 g3343 DC 0
V277 I4294 g3354 DC 0
V278 I3672 g3355 DC 0
V279 I4294 g3363 DC 0
V280 I3672 g3364 DC 0
V281 g1030 g1688 DC 0
V282 I3672 g3370 DC 0
V283 g1017 g1685 DC 0
V284 g1011 g1684 DC 0
V285 g1193 g2118 DC 0
V286 g1006 g1681 DC 0
V287 g1270 g2044 DC 0
V288 I2596 g1679 DC 0
V289 g1001 g1678 DC 0
V290 I2596 g1674 DC 0
V291 g680 g1673 DC 0
V292 I2596 g1671 DC 0
V293 g4124 g3440 DC 0
V294 g679 g1670 DC 0
V295 I4294 g3451 DC 0
V296 I4294 g3452 DC 0
V297 I3672 g3453 DC 0
V298 g4424 g3454 DC 0
V299 I4294 g3455 DC 0
V300 I3672 g3456 DC 0
V301 I4294 g3457 DC 0
V302 I3672 g3458 DC 0
V303 I4294 g3459 DC 0
V304 I3672 g3460 DC 0
V305 I2596 g1665 DC 0
V306 I4294 g3462 DC 0
V307 I3672 g3463 DC 0
V308 g678 g1664 DC 0
V309 I4294 g3477 DC 0
V310 I3672 g3478 DC 0
V311 g1143 g2088 DC 0
V312 I2596 g1660 DC 0
V313 I4294 g3482 DC 0
V314 I3672 g3483 DC 0
V315 g1123 g1659 DC 0
V316 g4809 g3486 DC 0
V317 g1222 g2134 DC 0
V318 I3672 g3488 DC 0
V319 g41 g3491 DC 0
V320 I2596 g1655 DC 0
V321 g639 g1654 DC 0
V322 g1143 g1653 DC 0
V323 g1209 g2135 DC 0
V324 I2596 g1649 DC 0
V325 g1161 g1648 DC 0
V326 g1236 g3527 DC 0
V327 g4122 g3534 DC 0
V328 g4123 g3537 DC 0
V329 g1177 g1647 DC 0
V330 g44 g3545 DC 0
V331 g45 g3546 DC 0
V332 g23 g3557 DC 0
V333 g22 g3559 DC 0
V334 g47 g3564 DC 0
V335 g37 g3567 DC 0
V336 g38 g3571 DC 0
V337 g39 g3589 DC 0
V338 g40 g3593 DC 0
V339 g4121 g3599 DC 0
V340 g43 g3600 DC 0
V341 g43 g3601 DC 0
V342 g485 g3604 DC 0
V343 g668 g3612 DC 0
V344 g1193 g1646 DC 0
V345 g1123 g1645 DC 0
V346 g1209 g1644 DC 0
V347 g46 g3638 DC 0
V348 g1143 g1643 DC 0
V349 g4426 g2041 DC 0
V350 g1222 g1641 DC 0
V351 g1161 g1640 DC 0
V352 g1177 g1636 DC 0
V353 g42 g3673 DC 0
V354 g705 g2040 DC 0
V355 g1193 g1631 DC 0
V356 g1236 g2154 DC 0
V357 g1209 g1623 DC 0
V358 g1 g3705 DC 0
V359 g2 g3710 DC 0
V360 g10 g3719 DC 0
V361 g42 g3766 DC 0
V362 g1222 g1608 DC 0
V363 g4657 g3768 DC 0
V364 g42 g3771 DC 0
V365 g2587 g1594 DC 0
V366 g485 g1593 DC 0
V367 g1222 g2155 DC 0
V368 g2586 g1587 DC 0
V369 g45 g3783 DC 0
V370 g668 g1586 DC 0
V371 g46 g3787 DC 0
V372 g1236 g2158 DC 0
V373 g1123 g2172 DC 0
V374 g1161 g2173 DC 0
V375 g1143 g2174 DC 0
V376 g1123 g2175 DC 0
V377 g1177 g2176 DC 0
V378 g668 g3803 DC 0
V379 g485 g3807 DC 0
V380 g4425 g3814 DC 0
V381 g4423 g3828 DC 0
V382 g1161 g2177 DC 0
V383 g28 g3832 DC 0
V384 g32 g3834 DC 0
V385 g14 g3835 DC 0
V386 g1236 g3836 DC 0
V387 g1 g3838 DC 0
V388 g36 g3839 DC 0
V389 g18 g3840 DC 0
V390 g4658 g3844 DC 0
V391 g1143 g2178 DC 0
V392 g2 g3846 DC 0
V393 g37 g3847 DC 0
V394 g24 g3848 DC 0
V395 g3714 g3852 DC 0
V396 g38 g3853 DC 0
V397 g28 g3854 DC 0
V398 g10 g3859 DC 0
V399 g39 g3860 DC 0
V400 g40 g3861 DC 0
V401 g567 g2179 DC 0
V402 g14 g3866 DC 0
V403 g1 g3867 DC 0
V404 g4124 g3874 DC 0
V405 g18 g3875 DC 0
V406 g2 g3876 DC 0
V407 g639 g1556 DC 0
V408 g24 g3881 DC 0
V409 g3714 g3882 DC 0
V410 g1193 g2194 DC 0
V411 g10 g3885 DC 0
V412 g1177 g2195 DC 0
V413 g1161 g2196 DC 0
V414 g3234 g2197 DC 0
V415 g4659 g3910 DC 0
V416 g639 g1549 DC 0
V417 g4424 g3922 DC 0
V418 g40 g3932 DC 0
V419 g1209 g2212 DC 0
V420 g32 g3940 DC 0
V421 g36 g3952 DC 0
V422 g639 g1542 DC 0
V423 g1193 g2213 DC 0
V424 g4122 g3960 DC 0
V425 g37 g3962 DC 0
V426 g42 g3963 DC 0
V427 g639 g1539 DC 0
V428 g1177 g2214 DC 0
V429 g4123 g3967 DC 0
V430 g38 g3969 DC 0
V431 g44 g3970 DC 0
V432 g39 g3975 DC 0
V433 g45 g3976 DC 0
V434 g46 g3980 DC 0
V435 g4426 g3984 DC 0
V436 g639 g1533 DC 0
V437 g23 g4014 DC 0
V438 g22 g4016 DC 0
V439 g41 g4034 DC 0
V440 g47 g4036 DC 0
V441 g4121 g4040 DC 0
V442 g23 g4098 DC 0
V443 g32 g4099 DC 0
V444 g36 g4100 DC 0
V445 g37 g4101 DC 0
V446 g38 g4102 DC 0
V447 g39 g4103 DC 0
V448 g22 g4104 DC 0
V449 g40 g4105 DC 0
V450 g42 g4106 DC 0
V451 g44 g4107 DC 0
V452 g45 g4108 DC 0
V453 g46 g4109 DC 0
V454 g41 g4110 DC 0
V455 g47 g4112 DC 0
V456 g42 g4125 DC 0
V457 g42 g4126 DC 0
V458 g45 g4127 DC 0
V459 g46 g4128 DC 0
V460 g1 g4129 DC 0
V461 g2 g4130 DC 0
V462 g3714 g4131 DC 0
V463 g10 g4132 DC 0
V464 g14 g4133 DC 0
V465 g18 g4134 DC 0
V466 g24 g4135 DC 0
V467 g28 g4136 DC 0
V468 g32 g4137 DC 0
V469 g36 g4138 DC 0
V470 g37 g4139 DC 0
V471 g38 g4140 DC 0
V472 g39 g4141 DC 0
V473 g1 g4142 DC 0
V474 g2 g4143 DC 0
V475 g3714 g4144 DC 0
V476 g10 g4145 DC 0
V477 g14 g4146 DC 0
V478 g18 g4147 DC 0
V479 g24 g4148 DC 0
V480 g28 g4149 DC 0
V481 g40 g4150 DC 0
V482 g4426 g4152 DC 0
V483 g4425 g4153 DC 0
V484 g4858 g4157 DC 0
V485 g3235 g2215 DC 0
V486 g639 g1528 DC 0
V487 g639 g1513 DC 0
V488 g1875 g1504 DC 0
V489 g639 g1503 DC 0
V490 g4659 g4194 DC 0
V491 g4657 g4213 DC 0
V492 g4857 g4219 DC 0
V493 g1049 g1498 DC 0
V494 g4423 g4228 DC 0
V495 g1222 g2230 DC 0
V496 g4658 g4249 DC 0
V497 g1209 g2231 DC 0
V498 I2596 g1480 DC 0
V499 g1193 g2232 DC 0
V500 g4424 g4299 DC 0
V501 g485 g4307 DC 0
V502 g485 g4308 DC 0
V503 g4809 g4320 DC 0
V504 g668 g4321 DC 0
V505 g668 g4322 DC 0
V506 g4809 g4343 DC 0
V507 g43 g4350 DC 0
V508 g564 g4422 DC 0
V509 g4846 g4430 DC 0
V510 g4847 g4433 DC 0
V511 g4856 g4434 DC 0
V512 g4848 g4436 DC 0
V513 g4849 g4438 DC 0
V514 g4841 g4440 DC 0
V515 g4850 g4441 DC 0
V516 g4842 g4443 DC 0
V517 g4851 g4444 DC 0
V518 g4843 g4446 DC 0
V519 g4852 g4447 DC 0
V520 g4844 g4450 DC 0
V521 g4853 g4451 DC 0
V522 g4845 g4454 DC 0
V523 g4854 g4455 DC 0
V524 g4855 g4458 DC 0
V525 g5147 g4460 DC 0
V526 g1161 g2233 DC 0
V527 g4858 g4492 DC 0
V528 g2312 g1461 DC 0
V529 g5148 g4501 DC 0
V530 g3236 g2234 DC 0
V531 g4659 g4514 DC 0
V532 g4657 g4519 DC 0
V533 g4857 g4562 DC 0
V534 g2312 g1450 DC 0
V535 g1236 g2241 DC 0
V536 g4809 g4603 DC 0
V537 g4658 g4609 DC 0
V538 I3102 I3617 DC 0
V539 g43 g4644 DC 0
V540 g1119 g465 DC 0
V541 I3102 I3614 DC 0
V542 g5328 g4687 DC 0
V543 g1222 g2242 DC 0
V544 g4846 g4692 DC 0
V545 g1209 g2243 DC 0
V546 g1381 g1395 DC 0
V547 g4847 g4699 DC 0
V548 g4856 g4700 DC 0
V549 g1372 g1391 DC 0
V550 g4848 g4702 DC 0
V551 g4849 g4703 DC 0
V552 g4841 g4704 DC 0
V553 g4850 g4705 DC 0
V554 g4842 g4706 DC 0
V555 g4851 g4707 DC 0
V556 g4843 g4711 DC 0
V557 g4852 g4712 DC 0
V558 g4844 g4714 DC 0
V559 g4853 g4715 DC 0
V560 g4845 g4718 DC 0
V561 g4854 g4719 DC 0
V562 g4855 g4721 DC 0
V563 g5147 g4758 DC 0
V564 g5329 g4761 DC 0
V565 g4858 g4765 DC 0
V566 g1348 g1378 DC 0
V567 g5148 g4781 DC 0
V568 g4857 g4798 DC 0
V569 g3541 g48 DC 0
V570 g4809 g4810 DC 0
V571 g485 g4822 DC 0
V572 g43 g4823 DC 0
V573 g668 g4824 DC 0
V574 g1381 g1366 DC 0
V575 g43 g4871 DC 0
V576 g5489 g4872 DC 0
V577 g1177 g2244 DC 0
V578 g5328 g5010 DC 0
V579 g1372 g1355 DC 0
V580 g5490 g5017 DC 0
V581 g5147 g5051 DC 0
V582 g1381 g1352 DC 0
V583 g5329 g5089 DC 0
V584 g3237 g2245 DC 0
V585 g5148 g5110 DC 0
V586 g1372 g1345 DC 0
V587 g485 g5135 DC 0
V588 g668 g5136 DC 0
V589 g43 g5137 DC 0
V590 g5580 g5149 DC 0
V591 g1123 g1344 DC 0
V592 g5019 g5151 DC 0
V593 g5581 g5167 DC 0
V594 I3102 I3620 DC 0
V595 I3102 I3623 DC 0
V596 g1363 g1341 DC 0
V597 I3102 I3632 DC 0
V598 I3102 I3635 DC 0
V599 I3102 I3638 DC 0
V600 I3102 I3641 DC 0
V601 g1143 g1340 DC 0
V602 I4294 I3650 DC 0
V603 I3102 I3653 DC 0
V604 I3102 I3656 DC 0
V605 I3102 I3659 DC 0
V606 g1123 g1339 DC 0
V607 g2586 I3665 DC 0
V608 I3102 I3675 DC 0
V609 g2587 I3681 DC 0
V610 g47 I2321 DC 0
V611 g1161 g1338 DC 0
V612 I3102 I2552 DC 0
V613 g1123 I3711 DC 0
V614 g1143 I3714 DC 0
V615 g23 I3726 DC 0
V616 g2586 I3729 DC 0
V617 g22 I3733 DC 0
V618 g2587 I3736 DC 0
V619 g41 I3746 DC 0
V620 g1143 g1337 DC 0
V621 I4294 I3755 DC 0
V622 g1236 g2252 DC 0
V623 g47 I3758 DC 0
V624 I4294 I3767 DC 0
V625 I3672 I3770 DC 0
V626 g5489 g5219 DC 0
V627 g1177 g1334 DC 0
V628 I4294 I3779 DC 0
V629 I3672 I3782 DC 0
V630 g3541 I3785 DC 0
V631 g5328 g5230 DC 0
V632 g5491 g5231 DC 0
V633 g1161 g1333 DC 0
V634 I4294 I3797 DC 0
V635 I3672 I3800 DC 0
V636 I4294 I3808 DC 0
V637 I3672 I3811 DC 0
V638 g1193 g1331 DC 0
V639 I4294 I3823 DC 0
V640 I3672 I3826 DC 0
V641 g1177 g1330 DC 0
V642 I3672 g1329 DC 0
V643 g2586 I3836 DC 0
V644 I4294 I3840 DC 0
V645 I3672 I3843 DC 0
V646 g1209 g1328 DC 0
V647 g2586 I3855 DC 0
V648 g5490 g5273 DC 0
V649 g5329 g5307 DC 0
V650 g2587 I3861 DC 0
V651 g485 g5314 DC 0
V652 g4809 g5315 DC 0
V653 g668 g5316 DC 0
V654 g1193 g1327 DC 0
V655 I4294 I3868 DC 0
V656 I3672 I3871 DC 0
V657 g2587 I3883 DC 0
V658 I3672 I3890 DC 0
V659 g5019 g5330 DC 0
V660 I4294 g1325 DC 0
V661 g2586 I4019 DC 0
V662 g2587 I4031 DC 0
V663 g1222 g1324 DC 0
V664 g1209 g1323 DC 0
V665 g4426 g1322 DC 0
V666 g485 g5355 DC 0
V667 g567 I2584 DC 0
V668 g668 g5358 DC 0
V669 g1236 g1321 DC 0
V670 g5580 g5375 DC 0
V671 g1222 g1320 DC 0
V672 g5581 g5383 DC 0
V673 g6282 g5385 DC 0
V674 g5582 g5386 DC 0
V675 g5489 g5387 DC 0
V676 g1222 g2253 DC 0
V677 g2587 I2608 DC 0
V678 g2586 I2614 DC 0
V679 g18 I4170 DC 0
V680 g5490 g5432 DC 0
V681 I4294 I2627 DC 0
V682 g2587 I2630 DC 0
V683 I3672 I2635 DC 0
V684 g24 I4189 DC 0
V685 g40 I4192 DC 0
V686 g2586 I2638 DC 0
V687 g1236 g1318 DC 0
V688 Vss g5452 DC 0
V689 g1193 g2254 DC 0
V690 g5491 g5466 DC 0
V691 g485 g5468 DC 0
V692 g668 g5469 DC 0
V693 g702 g1294 DC 0
V694 g699 g1293 DC 0
V695 g1 I4217 DC 0
V696 g28 I4220 DC 0
V697 I4294 I4226 DC 0
V698 g2587 I2364 DC 0
V699 g2586 I2370 DC 0
V700 g2 I4240 DC 0
V701 g666 g1290 DC 0
V702 g5584 g5531 DC 0
V703 g5587 g5532 DC 0
V704 g5590 g5533 DC 0
V705 g5580 g5534 DC 0
V706 g5593 g5535 DC 0
V707 g32 I4243 DC 0
V708 g5581 g5540 DC 0
V709 I4294 I4249 DC 0
V710 I3672 I4252 DC 0
V711 g3714 I4258 DC 0
V712 Vss g5566 DC 0
V713 g3239 g1287 DC 0
V714 g5582 g5579 DC 0
V715 g3238 g1286 DC 0
V716 Vss g5597 DC 0
V717 g36 I4261 DC 0
V718 g3235 g1285 DC 0
V719 g5702 g5622 DC 0
V720 g5705 g5624 DC 0
V721 g5708 g5625 DC 0
V722 g5711 g5626 DC 0
V723 g5714 g5627 DC 0
V724 g5717 g5628 DC 0
V725 g5720 g5629 DC 0
V726 g5723 g5630 DC 0
V727 g3237 g1284 DC 0
V728 g3236 g1283 DC 0
V729 g6282 g5645 DC 0
V730 I4294 I4267 DC 0
V731 I3672 I4270 DC 0
V732 g10 I4276 DC 0
V733 g3234 g1282 DC 0
V734 I4294 I4282 DC 0
V735 Vss g5692 DC 0
V736 g3241 g571 DC 0
V737 g3241 g1275 DC 0
V738 g3240 g1274 DC 0
V739 I3672 I4285 DC 0
V740 g1267 g574 DC 0
V741 g567 g1273 DC 0
V742 g5584 g5751 DC 0
V743 g5587 g5752 DC 0
V744 I3672 I4297 DC 0
V745 g5590 g5773 DC 0
V746 g5593 g5774 DC 0
V747 g1270 g578 DC 0
V748 g1257 g582 DC 0
V749 g1263 g586 DC 0
V750 g5584 g5875 DC 0
V751 g5590 g5876 DC 0
V752 g5587 g5877 DC 0
V753 g5593 g5878 DC 0
V754 g6282 g5879 DC 0
V755 g37 I4303 DC 0
V756 g42 I4306 DC 0
V757 g564 g1256 DC 0
V758 I4294 I4309 DC 0
V759 I3102 I3602 DC 0
V760 g1735 g1249 DC 0
V761 g1119 g1246 DC 0
V762 g1119 g1233 DC 0
V763 g15 g1232 DC 0
V764 g43 g1220 DC 0
V765 g11 g1219 DC 0
V766 g1276 g590 DC 0
V767 g1711 g1203 DC 0
V768 I3672 I4312 DC 0
V769 g1703 g1190 DC 0
V770 g14 I4318 DC 0
V771 g38 I4321 DC 0
V772 g1699 g1189 DC 0
V773 g5702 g5917 DC 0
V774 g5705 g5918 DC 0
V775 g5708 g5919 DC 0
V776 g5711 g5920 DC 0
V777 g5714 g5921 DC 0
V778 g5717 g5922 DC 0
V779 g5720 g5923 DC 0
V780 g5723 g5924 DC 0
V781 g44 I4324 DC 0
V782 g1279 g594 DC 0
V783 g1335 g1176 DC 0
V784 I4294 I4327 DC 0
V785 I3672 I4331 DC 0
V786 g3234 g598 DC 0
V787 g1696 g1173 DC 0
V788 g39 I4337 DC 0
V789 g3714 g6 DC 0
V790 g1332 g1160 DC 0
V791 g45 I4340 DC 0
V792 I3251 g602 DC 0
V793 g6282 g6032 DC 0
V794 g1692 g1156 DC 0
V795 I3672 g1142 DC 0
V796 I4294 g1122 DC 0
V797 g14 g1116 DC 0
V798 g10 g1114 DC 0
V799 I4294 I4343 DC 0
V800 g3714 g1113 DC 0
V801 g2 g1111 DC 0
V802 g28 g1110 DC 0
V803 I3672 I4347 DC 0
V804 g46 I4354 DC 0
V805 g1 g1109 DC 0
V806 g3237 g606 DC 0
V807 I4294 I4358 DC 0
V808 I3672 I4362 DC 0
V809 g705 g1108 DC 0
V810 I3672 I4371 DC 0
V811 g2586 I4398 DC 0
V812 g24 g1107 DC 0
V813 g2587 I4410 DC 0
V814 g2586 I4414 DC 0
V815 g2587 I4424 DC 0
V816 g2587 I2373 DC 0
V817 g18 g1106 DC 0
V818 g40 I2716 DC 0
V819 g564 I4468 DC 0
V820 g32 I2731 DC 0
V821 g36 I2735 DC 0
V822 g37 I2753 DC 0
V823 g42 I2756 DC 0
V824 g2586 I2379 DC 0
V825 g5702 g6100 DC 0
V826 g5705 g6101 DC 0
V827 g5711 g6102 DC 0
V828 g5720 g6103 DC 0
V829 g5708 g6104 DC 0
V830 g5714 g6105 DC 0
V831 g5717 g6106 DC 0
V832 g5723 g6107 DC 0
V833 g6284 g6110 DC 0
V834 I3102 I3599 DC 0
V835 I3102 I3596 DC 0
V836 I3102 I3593 DC 0
V837 g38 I2773 DC 0
V838 g44 I2776 DC 0
V839 g564 I4903 DC 0
V840 g3238 g2256 DC 0
V841 g639 I2388 DC 0
V842 g1236 g2264 DC 0
V843 g39 I2802 DC 0
V844 g1209 g2265 DC 0
V845 g45 I2805 DC 0
V846 g46 I2821 DC 0
V847 g6282 g6137 DC 0
V848 g2587 I2825 DC 0
V849 g2586 I2839 DC 0
V850 g6407 g6142 DC 0
V851 g2587 I2867 DC 0
V852 g2586 I2877 DC 0
V853 g2587 I2880 DC 0
V854 g2587 I2883 DC 0
V855 g2586 I2887 DC 0
V856 g2586 I2890 DC 0
V857 g2587 I3590 DC 0
V858 I2479 I2907 DC 0
V859 g2586 I2910 DC 0
V860 g2587 I2916 DC 0
V861 g2586 I2929 DC 0
V862 g2587 I2940 DC 0
V863 g40 I2943 DC 0
V864 g3239 g2268 DC 0
V865 I3102 I3581 DC 0
V866 I3102 I3578 DC 0
V867 I3102 I3575 DC 0
V868 I3102 I3572 DC 0
V869 g2586 I3569 DC 0
V870 g6364 g6167 DC 0
V871 g6368 g6170 DC 0
V872 g6370 g6173 DC 0
V873 g6372 g6176 DC 0
V874 g6374 g6179 DC 0
V875 g6360 g6182 DC 0
V876 g6362 g6185 DC 0
V877 g6366 g6189 DC 0
V878 g1222 g2275 DC 0
V879 g3240 g2276 DC 0
V880 I3102 I3556 DC 0
V881 I3102 I3553 DC 0
V882 g1123 I2946 DC 0
V883 I3102 I3550 DC 0
V884 g1143 I2952 DC 0
V885 g32 I2955 DC 0
V886 g1236 g2283 DC 0
V887 g36 I2961 DC 0
V888 I3102 I3537 DC 0
V889 g3241 g2284 DC 0
V890 g1875 g204 DC 0
V891 I3102 I2982 DC 0
V892 I3102 g2293 DC 0
V893 I3102 I3534 DC 0
V894 g4426 I5337 DC 0
V895 g564 I5415 DC 0
V896 g4426 I5418 DC 0
V897 g37 I2992 DC 0
V898 g42 I2995 DC 0
V899 Vdd I8878 DC 0
V900 g47 I5542 DC 0
V901 Vdd I8840 DC 0
V902 Vdd I8767 DC 0
V903 I3102 I3004 DC 0
V904 I3102 I3007 DC 0
V905 I3102 g2295 DC 0
V906 I3102 I3519 DC 0
V907 g6282 g6283 DC 0
V908 g6284 g6285 DC 0
V909 g6504 g6286 DC 0
V910 g6509 g6287 DC 0
V911 I3102 I3516 DC 0
V912 g6505 g6289 DC 0
V913 g6510 g6290 DC 0
V914 g6592 g6291 DC 0
V915 g6497 g6292 DC 0
V916 g6506 g6293 DC 0
V917 g6511 g6294 DC 0
V918 g6593 g6295 DC 0
V919 g6498 g6296 DC 0
V920 g6507 g6297 DC 0
V921 g6512 g6298 DC 0
V922 g6594 g6299 DC 0
V923 g6499 g6300 DC 0
V924 g6508 g6301 DC 0
V925 g6500 g6303 DC 0
V926 g6596 g6304 DC 0
V927 g6501 g6307 DC 0
V928 g6502 g6309 DC 0
V929 g6503 g6310 DC 0
V930 g38 I3016 DC 0
V931 g6407 g6312 DC 0
V932 g44 I3019 DC 0
V933 I3102 I3022 DC 0
V934 I3102 I3025 DC 0
V935 I3102 I3505 DC 0
V936 I3102 I3502 DC 0
V937 g39 I3037 DC 0
V938 g45 I3040 DC 0
V939 g47 I5929 DC 0
V940 g3541 I3496 DC 0
V941 g2312 g2308 DC 0
V942 I3102 I3047 DC 0
V943 I3102 I3050 DC 0
V944 I3102 I3488 DC 0
V945 g3235 g634 DC 0
V946 g43 g2315 DC 0
V947 g2584 g2316 DC 0
V948 g6360 g6361 DC 0
V949 g6362 g6363 DC 0
V950 g6364 g6365 DC 0
V951 g6366 g6367 DC 0
V952 g6368 g6369 DC 0
V953 g6370 g6371 DC 0
V954 g6372 g6373 DC 0
V955 g6374 g6375 DC 0
V956 I2596 g638 DC 0
V957 g46 I3062 DC 0
V958 g2312 g2317 DC 0
V959 g2312 g2320 DC 0
V960 g6509 g6410 DC 0
V961 g6504 g6411 DC 0
V962 g6510 g6412 DC 0
V963 g6505 g6413 DC 0
V964 g6511 g6414 DC 0
V965 g6497 g6415 DC 0
V966 g6506 g6416 DC 0
V967 g6512 g6417 DC 0
V968 g6498 g6418 DC 0
V969 g6507 g6419 DC 0
V970 g3236 g642 DC 0
V971 g6499 g6420 DC 0
V972 g6508 g6421 DC 0
V973 g6500 g6422 DC 0
V974 g6501 g6423 DC 0
V975 g6502 g6424 DC 0
V976 g6503 g6425 DC 0
V977 g6591 g6426 DC 0
V978 g6592 g6428 DC 0
V979 g6593 g6431 DC 0
V980 g6594 g6434 DC 0
V981 g6595 g6437 DC 0
V982 g6596 g6441 DC 0
V983 g3238 g646 DC 0
V984 I3102 I3065 DC 0
V985 I3102 I3068 DC 0
V986 g41 I2312 DC 0
V987 I3102 I3074 DC 0
V988 g6597 g6479 DC 0
V989 g6598 g6480 DC 0
V990 g6599 g6481 DC 0
V991 g6602 g6482 DC 0
V992 g6600 g6483 DC 0
V993 g6601 g6485 DC 0
V994 g3239 g650 DC 0
V995 g6282 g6515 DC 0
V996 g6284 g6516 DC 0
V997 g6601 g6519 DC 0
V998 g6602 g6521 DC 0
V999 g6597 g6523 DC 0
V1000 g6591 g6524 DC 0
V1001 g6598 g6525 DC 0
V1002 g6592 g6526 DC 0
V1003 g6599 g6527 DC 0
V1004 g6593 g6528 DC 0
V1005 g6594 g6529 DC 0
V1006 g6600 g6530 DC 0
V1007 g6595 g6531 DC 0
V1008 g6596 g6532 DC 0
V1009 I3102 I3077 DC 0
V1010 g3240 g654 DC 0
V1011 I3102 I2537 DC 0
V1012 I3102 I3083 DC 0
V1013 I3102 I3086 DC 0
V1014 g22 I2306 DC 0
V1015 I3102 I3093 DC 0
V1016 I3102 I3096 DC 0
V1017 g6360 g6574 DC 0
V1018 g6362 g6575 DC 0
V1019 g6364 g6576 DC 0
V1020 g6366 g6577 DC 0
V1021 g6368 g6578 DC 0
V1022 g6370 g6579 DC 0
V1023 I3102 g658 DC 0
V1024 g6372 g6580 DC 0
V1025 g6374 g6581 DC 0
V1026 g23 I2296 DC 0
V1027 Vss g6619 DC 0
V1028 I3102 I3105 DC 0
V1029 I3102 I2293 DC 0
V1030 g1288 g663 DC 0
V1031 I3102 I3112 DC 0
V1032 g2312 g2324 DC 0
V1033 g1291 g664 DC 0
V1034 g2312 g2327 DC 0
V1035 g2312 g2333 DC 0
V1036 g567 I3434 DC 0
V1037 I3102 I2290 DC 0
V1038 g2312 g2343 DC 0
V1039 g23 I3137 DC 0
V1040 g1292 g665 DC 0
V1041 g2312 g2347 DC 0
V1042 Vss g6657 DC 0
V1043 g6729 g6658 DC 0
V1044 g2587 I2172 DC 0
V1045 g22 I3140 DC 0
V1046 g1289 g667 DC 0
V1047 g41 I3144 DC 0
V1048 I3102 I2445 DC 0
V1049 g47 I3152 DC 0
V1050 I3102 I2449 DC 0
V1051 g6725 g6684 DC 0
V1052 g6726 g6685 DC 0
V1053 g6720 g6686 DC 0
V1054 g6727 g6687 DC 0
V1055 g6721 g6688 DC 0
V1056 g6722 g6689 DC 0
V1057 g6723 g6690 DC 0
V1058 g6724 g6691 DC 0
V1059 g6725 g6694 DC 0
V1060 g6726 g6695 DC 0
V1061 g6720 g6696 DC 0
V1062 g6727 g6697 DC 0
V1063 g6721 g6698 DC 0
V1064 g6722 g6699 DC 0
V1065 g6723 g6700 DC 0
V1066 g6724 g6701 DC 0
V1067 g6745 g6702 DC 0
V1068 g6744 g6704 DC 0
V1069 Vss g6710 DC 0
V1070 g6729 g6711 DC 0
V1071 g2587 I3325 DC 0
V1072 g1123 g2090 DC 0
V1073 g2312 g2357 DC 0
V1074 Vss g6728 DC 0
V1075 g6744 g6730 DC 0
V1076 I3251 I2464 DC 0
V1077 I3102 I2473 DC 0
V1078 I3102 I2476 DC 0
V1079 g6745 g6743 DC 0
V1080 I2521 g675 DC 0
V1081 g2312 g2361 DC 0
V1082 g2586 I2165 DC 0
V1083 g2586 I3198 DC 0
V1084 g678 g2370 DC 0
V1085 g2312 g677 DC 0
V1086 g2587 I3202 DC 0
V1087 g2586 I3206 DC 0
V1088 g2587 I3215 DC 0
V1089 g6800 g6774 DC 0
V1090 Vdd I7318 DC 0
V1091 g6801 g6778 DC 0
V1092 g6800 g6785 DC 0
V1093 g6801 g6786 DC 0
V1094 g6824 g6787 DC 0
V1095 g6825 g6788 DC 0
V1096 g6826 g6789 DC 0
V1097 g6827 g6790 DC 0
V1098 g6803 g6791 DC 0
V1099 g6806 g6792 DC 0
V1100 g6809 g6793 DC 0
V1101 g6812 g6794 DC 0
V1102 g6800 g6796 DC 0
V1103 g6801 g6797 DC 0
V1104 g1001 g681 DC 0
V1105 g6824 g6817 DC 0
V1106 g6825 g6818 DC 0
V1107 g6826 g6819 DC 0
V1108 g1006 g682 DC 0
V1109 g6827 g6820 DC 0
V1110 g2312 g2378 DC 0
V1111 g485 g2390 DC 0
V1112 Vdd I7361 DC 0
V1113 g1011 g683 DC 0
V1114 g6812 g6832 DC 0
V1115 g6803 g6833 DC 0
V1116 g6800 g6834 DC 0
V1117 g6806 g6835 DC 0
V1118 g6809 g6836 DC 0
V1119 g6801 g6837 DC 0
V1120 g6812 g6838 DC 0
V1121 g6803 g6839 DC 0
V1122 g1017 g684 DC 0
V1123 g6806 g6840 DC 0
V1124 g6809 g6841 DC 0
V1125 g6812 g6842 DC 0
V1126 g6853 g6844 DC 0
V1127 g6854 g6845 DC 0
V1128 g6853 g6849 DC 0
V1129 g1030 g685 DC 0
V1130 g6854 g6850 DC 0
V1131 g1076 g687 DC 0
V1132 g1088 g688 DC 0
V1133 g1094 g689 DC 0
V1134 g1123 g690 DC 0
V1135 g1143 g691 DC 0
V1136 g1161 g692 DC 0
V1137 g1177 g693 DC 0
V1138 g1193 g694 DC 0
V1139 g1209 g695 DC 0
V1140 g1222 g696 DC 0
V1141 g1236 g697 DC 0
V1142 g1101 g698 DC 0
V1143 g1711 g7 DC 0
V1144 g1372 g719 DC 0
V1145 g1363 g729 DC 0
V1146 g1375 g736 DC 0
V1147 g208 g743 DC 0
V1148 g209 g749 DC 0
V1149 g210 g754 DC 0
V1150 g211 g760 DC 0
V1151 g1875 g766 DC 0
V1152 g1381 g774 DC 0
V1153 g1348 g784 DC 0
V1154 g1384 g791 DC 0
V1155 g280 g798 DC 0
V1156 g281 g804 DC 0
V1157 g282 g809 DC 0
V1158 g283 g815 DC 0
V1159 g1519 g821 DC 0
V1160 g2586 I3316 DC 0
V1161 g2587 I3313 DC 0
V1162 g679 g2397 DC 0
V1163 g2312 g2405 DC 0
V1164 g668 g2408 DC 0
V1165 g3541 g894 DC 0
V1166 g1519 g2004 DC 0
V1167 g4426 g898 DC 0
V1168 g1288 g899 DC 0
V1169 g1292 g900 DC 0
V1170 g1289 g908 DC 0
V1171 g666 g909 DC 0
V1172 g1291 g917 DC 0
V1173 I4294 I3255 DC 0
V1174 g699 g922 DC 0
V1175 I3672 I3268 DC 0
V1176 g702 g927 DC 0
V1177 g18 I3278 DC 0
V1178 Vdd I7451 DC 0
V1179 g24 I3284 DC 0
V1180 g1 I3288 DC 0
V1181 g28 I3291 DC 0
V1182 g680 g2422 DC 0
V1183 g2312 g2430 DC 0
V1184 g2 I3294 DC 0
V1185 g2586 I3307 DC 0
V1186 g3714 I3298 DC 0
V1187 g2312 g952 DC 0
V1188 g678 g965 DC 0
V1189 g14 I3304 DC 0
V1190 g679 g980 DC 0
V1191 g10 I3301 DC 0
V1192 g680 g996 DC 0

************************
* end of SPICE netlist *
************************

* Anti-Floating Pull-Downs (GMIN)
R_PD_0 96 0 100meg
R_PD_1 177 0 100meg
R_PD_2 187 0 100meg
R_PD_3 157 0 100meg
R_PD_4 g4846 0 100meg
R_PD_5 275 0 100meg
R_PD_6 117 0 100meg
R_PD_7 38 0 100meg
R_PD_8 g6727 0 100meg
R_PD_9 g6729 0 100meg
R_PD_10 g4850 0 100meg
R_PD_11 g1735 0 100meg
R_PD_12 225 0 100meg
R_PD_13 259 0 100meg
R_PD_14 109 0 100meg
R_PD_15 g37 0 100meg
R_PD_16 g1049 0 100meg
R_PD_17 72 0 100meg
R_PD_18 g1381 0 100meg
R_PD_19 313 0 100meg
R_PD_20 g5711 0 100meg
R_PD_21 g5714 0 100meg
R_PD_22 g1335 0 100meg
R_PD_23 161 0 100meg
R_PD_24 304 0 100meg
R_PD_25 g6511 0 100meg
R_PD_26 76 0 100meg
R_PD_27 g622 0 100meg
R_PD_28 211 0 100meg
R_PD_29 g1006 0 100meg
R_PD_30 g6824 0 100meg
R_PD_31 200 0 100meg
R_PD_32 229 0 100meg
R_PD_33 239 0 100meg
R_PD_34 g4124 0 100meg
R_PD_35 102 0 100meg
R_PD_36 52 0 100meg
R_PD_37 127 0 100meg
R_PD_38 321 0 100meg
R_PD_39 43 0 100meg
R_PD_40 g218 0 100meg
R_PD_41 242 0 100meg
R_PD_42 135 0 100meg
R_PD_43 222 0 100meg
R_PD_44 61 0 100meg
R_PD_45 g102 0 100meg
R_PD_46 324 0 100meg
R_PD_47 215 0 100meg
R_PD_48 g43 0 100meg
R_PD_49 g6744 0 100meg
R_PD_50 48 0 100meg
R_PD_51 g282 0 100meg
R_PD_52 g1348 0 100meg
R_PD_53 228 0 100meg
R_PD_54 g1161 0 100meg
R_PD_55 g1384 0 100meg
R_PD_56 106 0 100meg
R_PD_57 58 0 100meg
R_PD_58 g4423 0 100meg
R_PD_59 g524 0 100meg
R_PD_60 230 0 100meg
R_PD_61 260 0 100meg
R_PD_62 g6497 0 100meg
R_PD_63 10 0 100meg
R_PD_64 g672 0 100meg
R_PD_65 g520 0 100meg
R_PD_66 56 0 100meg
R_PD_67 g283 0 100meg
R_PD_68 g2 0 100meg
R_PD_69 68 0 100meg
R_PD_70 g281 0 100meg
R_PD_71 g4424 0 100meg
R_PD_72 208 0 100meg
R_PD_73 37 0 100meg
R_PD_74 134 0 100meg
R_PD_75 3 0 100meg
R_PD_76 20 0 100meg
R_PD_77 276 0 100meg
R_PD_78 g1094 0 100meg
R_PD_79 g40 0 100meg
R_PD_80 307 0 100meg
R_PD_81 g1288 0 100meg
R_PD_82 g1017 0 100meg
R_PD_83 214 0 100meg
R_PD_84 g5148 0 100meg
R_PD_85 165 0 100meg
R_PD_86 271 0 100meg
R_PD_87 180 0 100meg
R_PD_88 142 0 100meg
R_PD_89 151 0 100meg
R_PD_90 g1101 0 100meg
R_PD_91 302 0 100meg
R_PD_92 g6803 0 100meg
R_PD_93 17 0 100meg
R_PD_94 g4844 0 100meg
R_PD_95 166 0 100meg
R_PD_96 36 0 100meg
R_PD_97 g6593 0 100meg
R_PD_98 g6504 0 100meg
R_PD_99 138 0 100meg
R_PD_100 202 0 100meg
R_PD_101 322 0 100meg
R_PD_102 g1372 0 100meg
R_PD_103 257 0 100meg
R_PD_104 g4657 0 100meg
R_PD_105 236 0 100meg
R_PD_106 261 0 100meg
R_PD_107 325 0 100meg
R_PD_108 53 0 100meg
R_PD_109 59 0 100meg
R_PD_110 113 0 100meg
R_PD_111 310 0 100meg
R_PD_112 128 0 100meg
R_PD_113 287 0 100meg
R_PD_114 g6825 0 100meg
R_PD_115 g5329 0 100meg
R_PD_116 g4854 0 100meg
R_PD_117 g457 0 100meg
R_PD_118 318 0 100meg
R_PD_119 125 0 100meg
R_PD_120 g410 0 100meg
R_PD_121 255 0 100meg
R_PD_122 92 0 100meg
R_PD_123 22 0 100meg
R_PD_124 g3239 0 100meg
R_PD_125 44 0 100meg
R_PD_126 71 0 100meg
R_PD_127 g679 0 100meg
R_PD_128 256 0 100meg
R_PD_129 262 0 100meg
R_PD_130 g5717 0 100meg
R_PD_131 41 0 100meg
R_PD_132 209 0 100meg
R_PD_133 130 0 100meg
R_PD_134 g1375 0 100meg
R_PD_135 152 0 100meg
R_PD_136 g449 0 100meg
R_PD_137 104 0 100meg
R_PD_138 g1030 0 100meg
R_PD_139 111 0 100meg
R_PD_140 237 0 100meg
R_PD_141 277 0 100meg
R_PD_142 g41 0 100meg
R_PD_143 243 0 100meg
R_PD_144 31 0 100meg
R_PD_145 g5593 0 100meg
R_PD_146 g406 0 100meg
R_PD_147 g6722 0 100meg
R_PD_148 Q 0 100meg
R_PD_149 159 0 100meg
R_PD_150 g6594 0 100meg
R_PD_151 g430 0 100meg
R_PD_152 g6600 0 100meg
R_PD_153 27 0 100meg
R_PD_154 g1236 0 100meg
R_PD_155 78 0 100meg
R_PD_156 g5489 0 100meg
R_PD_157 g4848 0 100meg
R_PD_158 g5582 0 100meg
R_PD_159 323 0 100meg
R_PD_160 g1267 0 100meg
R_PD_161 13 0 100meg
R_PD_162 g6407 0 100meg
R_PD_163 g6720 0 100meg
R_PD_164 g1123 0 100meg
R_PD_165 178 0 100meg
R_PD_166 g45 0 100meg
R_PD_167 g4426 0 100meg
R_PD_168 g4809 0 100meg
R_PD_169 162 0 100meg
R_PD_170 g3237 0 100meg
R_PD_171 300 0 100meg
R_PD_172 253 0 100meg
R_PD_173 g1519 0 100meg
R_PD_174 21 0 100meg
R_PD_175 269 0 100meg
R_PD_176 169 0 100meg
R_PD_177 g4852 0 100meg
R_PD_178 g666 0 100meg
R_PD_179 65 0 100meg
R_PD_180 g6601 0 100meg
R_PD_181 327 0 100meg
R_PD_182 g2312 0 100meg
R_PD_183 87 0 100meg
R_PD_184 g619 0 100meg
R_PD_185 280 0 100meg
R_PD_186 136 0 100meg
R_PD_187 g669 0 100meg
R_PD_188 g508 0 100meg
R_PD_189 g4425 0 100meg
R_PD_190 232 0 100meg
R_PD_191 g6502 0 100meg
R_PD_192 g212 0 100meg
R_PD_193 244 0 100meg
R_PD_194 g260 0 100meg
R_PD_195 g32 0 100meg
R_PD_196 I2521 0 100meg
R_PD_197 66 0 100meg
R_PD_198 51 0 100meg
R_PD_199 g1119 0 100meg
R_PD_200 g6726 0 100meg
R_PD_201 26 0 100meg
R_PD_202 279 0 100meg
R_PD_203 107 0 100meg
R_PD_204 g557 0 100meg
R_PD_205 1 0 100meg
R_PD_206 100 0 100meg
R_PD_207 301 0 100meg
R_PD_208 g631 0 100meg
R_PD_209 g1711 0 100meg
R_PD_210 235 0 100meg
R_PD_211 g3234 0 100meg
R_PD_212 116 0 100meg
R_PD_213 267 0 100meg
R_PD_214 293 0 100meg
R_PD_215 g4123 0 100meg
R_PD_216 144 0 100meg
R_PD_217 89 0 100meg
R_PD_218 153 0 100meg
R_PD_219 g545 0 100meg
R_PD_220 121 0 100meg
R_PD_221 149 0 100meg
R_PD_222 97 0 100meg
R_PD_223 g15 0 100meg
R_PD_224 g426 0 100meg
R_PD_225 g5708 0 100meg
R_PD_226 15 0 100meg
R_PD_227 g236 0 100meg
R_PD_228 314 0 100meg
R_PD_229 238 0 100meg
R_PD_230 4 0 100meg
R_PD_231 g471 0 100meg
R_PD_232 g4857 0 100meg
R_PD_233 g414 0 100meg
R_PD_234 g6853 0 100meg
R_PD_235 g11 0 100meg
R_PD_236 201 0 100meg
R_PD_237 g22 0 100meg
R_PD_238 7 0 100meg
R_PD_239 231 0 100meg
R_PD_240 246 0 100meg
R_PD_241 207 0 100meg
R_PD_242 150 0 100meg
R_PD_243 g6725 0 100meg
R_PD_244 g6723 0 100meg
R_PD_245 g3541 0 100meg
R_PD_246 g6501 0 100meg
R_PD_247 254 0 100meg
R_PD_248 g554 0 100meg
R_PD_249 g14 0 100meg
R_PD_250 306 0 100meg
R_PD_251 g4658 0 100meg
R_PD_252 316 0 100meg
R_PD_253 g516 0 100meg
R_PD_254 263 0 100meg
R_PD_255 192 0 100meg
R_PD_256 g422 0 100meg
R_PD_257 309 0 100meg
R_PD_258 g418 0 100meg
R_PD_259 298 0 100meg
R_PD_260 34 0 100meg
R_PD_261 219 0 100meg
R_PD_262 g1193 0 100meg
R_PD_263 g3241 0 100meg
R_PD_264 241 0 100meg
R_PD_265 290 0 100meg
R_PD_266 g4853 0 100meg
R_PD_267 299 0 100meg
R_PD_268 245 0 100meg
R_PD_269 g4843 0 100meg
R_PD_270 172 0 100meg
R_PD_271 g6721 0 100meg
R_PD_272 223 0 100meg
R_PD_273 190 0 100meg
R_PD_274 g1292 0 100meg
R_PD_275 252 0 100meg
R_PD_276 88 0 100meg
R_PD_277 g6599 0 100meg
R_PD_278 93 0 100meg
R_PD_279 g6512 0 100meg
R_PD_280 g1143 0 100meg
R_PD_281 g3714 0 100meg
R_PD_282 g1703 0 100meg
R_PD_283 249 0 100meg
R_PD_284 g532 0 100meg
R_PD_285 251 0 100meg
R_PD_286 32 0 100meg
R_PD_287 g6506 0 100meg
R_PD_288 182 0 100meg
R_PD_289 14 0 100meg
R_PD_290 g500 0 100meg
R_PD_291 g558 0 100meg
R_PD_292 175 0 100meg
R_PD_293 84 0 100meg
R_PD_294 274 0 100meg
R_PD_295 185 0 100meg
R_PD_296 g434 0 100meg
R_PD_297 191 0 100meg
R_PD_298 296 0 100meg
R_PD_299 g662 0 100meg
R_PD_300 g4855 0 100meg
R_PD_301 g1363 0 100meg
R_PD_302 176 0 100meg
R_PD_303 g6498 0 100meg
R_PD_304 g4121 0 100meg
R_PD_305 g6500 0 100meg
R_PD_306 295 0 100meg
R_PD_307 194 0 100meg
R_PD_308 g5590 0 100meg
R_PD_309 g1279 0 100meg
R_PD_310 233 0 100meg
R_PD_311 317 0 100meg
R_PD_312 g6366 0 100meg
R_PD_313 234 0 100meg
R_PD_314 148 0 100meg
R_PD_315 I4294 0 100meg
R_PD_316 60 0 100meg
R_PD_317 g560 0 100meg
R_PD_318 266 0 100meg
R_PD_319 g6368 0 100meg
R_PD_320 55 0 100meg
R_PD_321 g4847 0 100meg
R_PD_322 g536 0 100meg
R_PD_323 39 0 100meg
R_PD_324 18 0 100meg
R_PD_325 179 0 100meg
R_PD_326 g1076 0 100meg
R_PD_327 126 0 100meg
R_PD_328 158 0 100meg
R_PD_329 g6360 0 100meg
R_PD_330 D 0 100meg
R_PD_331 I3672 0 100meg
R_PD_332 137 0 100meg
R_PD_333 23 0 100meg
R_PD_334 g639 0 100meg
R_PD_335 30 0 100meg
R_PD_336 221 0 100meg
R_PD_337 167 0 100meg
R_PD_338 g5490 0 100meg
R_PD_339 132 0 100meg
R_PD_340 g486 0 100meg
R_PD_341 29 0 100meg
R_PD_342 90 0 100meg
R_PD_343 294 0 100meg
R_PD_344 g504 0 100meg
R_PD_345 6 0 100meg
R_PD_346 216 0 100meg
R_PD_347 146 0 100meg
R_PD_348 g6370 0 100meg
R_PD_349 g2587 0 100meg
R_PD_350 64 0 100meg
R_PD_351 g6503 0 100meg
R_PD_352 g628 0 100meg
R_PD_353 73 0 100meg
R_PD_354 164 0 100meg
R_PD_355 g280 0 100meg
R_PD_356 g541 0 100meg
R_PD_357 g6499 0 100meg
R_PD_358 g4122 0 100meg
R_PD_359 156 0 100meg
R_PD_360 264 0 100meg
R_PD_361 131 0 100meg
R_PD_362 g668 0 100meg
R_PD_363 g1291 0 100meg
R_PD_364 115 0 100meg
R_PD_365 160 0 100meg
R_PD_366 186 0 100meg
R_PD_367 g6724 0 100meg
R_PD_368 g6508 0 100meg
R_PD_369 147 0 100meg
R_PD_370 74 0 100meg
R_PD_371 46 0 100meg
R_PD_372 247 0 100meg
R_PD_373 g6592 0 100meg
R_PD_374 198 0 100meg
R_PD_375 g6509 0 100meg
R_PD_376 170 0 100meg
R_PD_377 173 0 100meg
R_PD_378 g5580 0 100meg
R_PD_379 288 0 100meg
R_PD_380 124 0 100meg
R_PD_381 g5702 0 100meg
R_PD_382 g6801 0 100meg
R_PD_383 240 0 100meg
R_PD_384 8 0 100meg
R_PD_385 g678 0 100meg
R_PD_386 g6364 0 100meg
R_PD_387 g702 0 100meg
R_PD_388 227 0 100meg
R_PD_389 265 0 100meg
R_PD_390 99 0 100meg
R_PD_391 g5491 0 100meg
R_PD_392 199 0 100meg
R_PD_393 g478 0 100meg
R_PD_394 g5581 0 100meg
R_PD_395 54 0 100meg
R_PD_396 108 0 100meg
R_PD_397 g676 0 100meg
R_PD_398 I3102 0 100meg
R_PD_399 g18 0 100meg
R_PD_400 217 0 100meg
R_PD_401 g1177 0 100meg
R_PD_402 g5705 0 100meg
R_PD_403 g4858 0 100meg
R_PD_404 g512 0 100meg
R_PD_405 112 0 100meg
R_PD_406 283 0 100meg
R_PD_407 86 0 100meg
R_PD_408 g6595 0 100meg
R_PD_409 g4851 0 100meg
R_PD_410 28 0 100meg
R_PD_411 120 0 100meg
R_PD_412 g1289 0 100meg
R_PD_413 226 0 100meg
R_PD_414 g36 0 100meg
R_PD_415 g3235 0 100meg
R_PD_416 118 0 100meg
R_PD_417 212 0 100meg
R_PD_418 303 0 100meg
R_PD_419 33 0 100meg
R_PD_420 98 0 100meg
R_PD_421 297 0 100meg
R_PD_422 g496 0 100meg
R_PD_423 g1222 0 100meg
R_PD_424 g5584 0 100meg
R_PD_425 94 0 100meg
R_PD_426 171 0 100meg
R_PD_427 g6812 0 100meg
R_PD_428 155 0 100meg
R_PD_429 g47 0 100meg
R_PD_430 g1699 0 100meg
R_PD_431 273 0 100meg
R_PD_432 g613 0 100meg
R_PD_433 189 0 100meg
R_PD_434 g445 0 100meg
R_PD_435 g441 0 100meg
R_PD_436 139 0 100meg
R_PD_437 80 0 100meg
R_PD_438 286 0 100meg
R_PD_439 292 0 100meg
R_PD_440 45 0 100meg
R_PD_441 g567 0 100meg
R_PD_442 g39 0 100meg
R_PD_443 g4845 0 100meg
R_PD_444 g485 0 100meg
R_PD_445 248 0 100meg
R_PD_446 213 0 100meg
R_PD_447 g4659 0 100meg
R_PD_448 49 0 100meg
R_PD_449 62 0 100meg
R_PD_450 122 0 100meg
R_PD_451 g211 0 100meg
R_PD_452 205 0 100meg
R_PD_453 g6372 0 100meg
R_PD_454 g4849 0 100meg
R_PD_455 g6510 0 100meg
R_PD_456 220 0 100meg
R_PD_457 319 0 100meg
R_PD_458 g6826 0 100meg
R_PD_459 g1001 0 100meg
R_PD_460 203 0 100meg
R_PD_461 g4842 0 100meg
R_PD_462 143 0 100meg
R_PD_463 67 0 100meg
R_PD_464 278 0 100meg
R_PD_465 312 0 100meg
R_PD_466 g242 0 100meg
R_PD_467 272 0 100meg
R_PD_468 g625 0 100meg
R_PD_469 g6598 0 100meg
R_PD_470 281 0 100meg
R_PD_471 g6597 0 100meg
R_PD_472 291 0 100meg
R_PD_473 328 0 100meg
R_PD_474 g6596 0 100meg
R_PD_475 5 0 100meg
R_PD_476 I2596 0 100meg
R_PD_477 101 0 100meg
R_PD_478 g5723 0 100meg
R_PD_479 g2584 0 100meg
R_PD_480 174 0 100meg
R_PD_481 g3238 0 100meg
R_PD_482 258 0 100meg
R_PD_483 g1088 0 100meg
R_PD_484 g1332 0 100meg
R_PD_485 g5019 0 100meg
R_PD_486 g1 0 100meg
R_PD_487 g230 0 100meg
R_PD_488 69 0 100meg
R_PD_489 50 0 100meg
R_PD_490 184 0 100meg
R_PD_491 110 0 100meg
R_PD_492 g4841 0 100meg
R_PD_493 119 0 100meg
R_PD_494 g210 0 100meg
R_PD_495 g89 0 100meg
R_PD_496 g28 0 100meg
R_PD_497 181 0 100meg
R_PD_498 g6806 0 100meg
R_PD_499 24 0 100meg
R_PD_500 57 0 100meg
R_PD_501 g564 0 100meg
R_PD_502 9 0 100meg
R_PD_503 g3236 0 100meg
R_PD_504 g5587 0 100meg
R_PD_505 g561 0 100meg
R_PD_506 12 0 100meg
R_PD_507 g699 0 100meg
R_PD_508 140 0 100meg
R_PD_509 g6374 0 100meg
R_PD_510 103 0 100meg
R_PD_511 40 0 100meg
R_PD_512 g254 0 100meg
R_PD_513 195 0 100meg
R_PD_514 g3240 0 100meg
R_PD_515 I2479 0 100meg
R_PD_516 g46 0 100meg
R_PD_517 285 0 100meg
R_PD_518 g5328 0 100meg
R_PD_519 83 0 100meg
R_PD_520 g1263 0 100meg
R_PD_521 210 0 100meg
R_PD_522 g489 0 100meg
R_PD_523 2 0 100meg
R_PD_524 g42 0 100meg
R_PD_525 g1257 0 100meg
R_PD_526 308 0 100meg
R_PD_527 g6602 0 100meg
R_PD_528 75 0 100meg
R_PD_529 141 0 100meg
R_PD_530 g1011 0 100meg
R_PD_531 g1875 0 100meg
R_PD_532 82 0 100meg
R_PD_533 105 0 100meg
R_PD_534 g6800 0 100meg
R_PD_535 168 0 100meg
R_PD_536 g1696 0 100meg
R_PD_537 85 0 100meg
R_PD_538 g402 0 100meg
R_PD_539 311 0 100meg
R_PD_540 79 0 100meg
R_PD_541 154 0 100meg
R_PD_542 g6809 0 100meg
R_PD_543 204 0 100meg
R_PD_544 g6282 0 100meg
R_PD_545 224 0 100meg
R_PD_546 16 0 100meg
R_PD_547 g548 0 100meg
R_PD_548 70 0 100meg
R_PD_549 g6505 0 100meg
R_PD_550 g2586 0 100meg
R_PD_551 163 0 100meg
R_PD_552 193 0 100meg
R_PD_553 77 0 100meg
R_PD_554 183 0 100meg
R_PD_555 g610 0 100meg
R_PD_556 g453 0 100meg
R_PD_557 35 0 100meg
R_PD_558 g209 0 100meg
R_PD_559 g437 0 100meg
R_PD_560 g6362 0 100meg
R_PD_561 188 0 100meg
R_PD_562 114 0 100meg
R_PD_563 145 0 100meg
R_PD_564 206 0 100meg
R_PD_565 CK 0 100meg
R_PD_566 g1209 0 100meg
R_PD_567 218 0 100meg
R_PD_568 g248 0 100meg
R_PD_569 g559 0 100meg
R_PD_570 g6745 0 100meg
R_PD_571 197 0 100meg
R_PD_572 g5147 0 100meg
R_PD_573 g528 0 100meg
R_PD_574 47 0 100meg
R_PD_575 326 0 100meg
R_PD_576 63 0 100meg
R_PD_577 81 0 100meg
R_PD_578 g551 0 100meg
R_PD_579 42 0 100meg
R_PD_580 315 0 100meg
R_PD_581 g1270 0 100meg
R_PD_582 g6854 0 100meg
R_PD_583 g1276 0 100meg
R_PD_584 123 0 100meg
R_PD_585 25 0 100meg
R_PD_586 g680 0 100meg
R_PD_587 g10 0 100meg
R_PD_588 g5720 0 100meg
R_PD_589 305 0 100meg
R_PD_590 g24 0 100meg
R_PD_591 284 0 100meg
R_PD_592 289 0 100meg
R_PD_593 g224 0 100meg
R_PD_594 196 0 100meg
R_PD_595 g6827 0 100meg
R_PD_596 g616 0 100meg
R_PD_597 268 0 100meg
R_PD_598 270 0 100meg
R_PD_599 19 0 100meg
R_PD_600 250 0 100meg
R_PD_601 g6284 0 100meg
R_PD_602 g562 0 100meg
R_PD_603 g1692 0 100meg
R_PD_604 129 0 100meg
R_PD_605 95 0 100meg
R_PD_606 329 0 100meg
R_PD_607 g492 0 100meg
R_PD_608 g6591 0 100meg
R_PD_609 g4856 0 100meg
R_PD_610 g461 0 100meg
R_PD_611 g6507 0 100meg
R_PD_612 g38 0 100meg
R_PD_613 320 0 100meg
R_PD_614 91 0 100meg
R_PD_615 g563 0 100meg
R_PD_616 282 0 100meg
R_PD_617 I3251 0 100meg
R_PD_618 11 0 100meg
R_PD_619 133 0 100meg
R_PD_620 g208 0 100meg

* Transient Simulation Directive
.TRAN 100p 10n
