* Nangila SPICE Auto-Synthesized Netlist
.SUBCKT INV_X1 A Z
M1 Z A 0 0 NMOS W=0.2u L=0.05u
M2 Z A 1 1 PMOS W=0.4u L=0.05u
.ENDS

.SUBCKT NAND2_X1 A1 A2 Z
M1 Z A1 1 1 PMOS W=0.4u L=0.05u
M2 Z A2 1 1 PMOS W=0.4u L=0.05u
M3 Z A1 int 0 NMOS W=0.2u L=0.05u
M4 int A2 0 0 NMOS W=0.2u L=0.05u
.ENDS

.SUBCKT AND2_X1 A1 A2 Z
X1 A1 A2 Z_bar NAND2_X1
X2 Z_bar Z INV_X1
.ENDS

.SUBCKT NOR2_X1 A1 A2 Z
M1 int1 A1 1 1 PMOS W=0.4u L=0.05u
M2 Z A2 int1 1 PMOS W=0.4u L=0.05u
M3 Z A1 0 0 NMOS W=0.2u L=0.05u
M4 Z A2 0 0 NMOS W=0.2u L=0.05u
.ENDS

.SUBCKT OR2_X1 A1 A2 Z
X1 A1 A2 Z_bar NOR2_X1
X2 Z_bar Z INV_X1
.ENDS

.SUBCKT XOR2_X1 A1 A2 Z
X1 A1 A2 int1 AND2_X1
X2 A1 A2 int2 NOR2_X1
X3 int1 int2 int3 NOR2_X1
X4 int3 Z INV_X1
.ENDS

.SUBCKT XNOR2_X1 A B Z
X1 A B Z_int XOR2_X1
X2 Z_int Z INV_X1
.ENDS

.SUBCKT BUF_X1 A Z
X1 A Z_bar INV_X1
X2 Z_bar Z INV_X1
.ENDS

.SUBCKT OAI21_X1 A B C Z
X1 A B C Z_bar AOI21_X1
X2 Z_bar Z INV_X1
.ENDS

.SUBCKT AOI21_X1 A B C Z
M1 Z A int1 1 PMOS W=0.4u L=0.05u
M2 int1 B 1 1 PMOS W=0.4u L=0.05u
M3 Z C 1 1 PMOS W=0.4u L=0.05u
M4 Z A 0 0 NMOS W=0.2u L=0.05u
M5 Z B 0 0 NMOS W=0.2u L=0.05u
M6 Z C 0 0 NMOS W=0.2u L=0.05u
.ENDS

.SUBCKT NAND3_X1 A1 A2 A3 Z
X1 A1 A2 int1 AND2_X1
X2 int1 A3 Z NAND2_X1
.ENDS

.SUBCKT AND3_X1 A1 A2 A3 Z
X1 A1 A2 A3 Z_bar NAND3_X1
X2 Z_bar Z INV_X1
.ENDS

.SUBCKT NOR3_X1 A1 A2 A3 Z
X1 A1 A2 int1 OR2_X1
X2 int1 A3 Z NOR2_X1
.ENDS

.SUBCKT OR3_X1 A1 A2 A3 Z
X1 A1 A2 A3 Z_bar NOR3_X1
X2 Z_bar Z INV_X1
.ENDS

.SUBCKT NAND4_X1 A1 A2 A3 A4 Z
X1 A1 A2 A3 int1 AND3_X1
X2 int1 A4 Z NAND2_X1
.ENDS

.SUBCKT AND4_X1 A1 A2 A3 A4 Z
X1 A1 A2 A3 A4 Z_bar NAND4_X1
X2 Z_bar Z INV_X1
.ENDS

.SUBCKT NOR4_X1 A1 A2 A3 A4 Z
X1 A1 A2 A3 int1 OR3_X1
X2 int1 A4 Z NOR2_X1
.ENDS

.SUBCKT OR4_X1 A1 A2 A3 A4 Z
X1 A1 A2 A3 A4 Z_bar NOR4_X1
X2 Z_bar Z INV_X1
.ENDS

.SUBCKT AOI22_X1 A B C D Z
X1 A B int1 AND2_X1
X2 C D int2 AND2_X1
X3 int1 int2 Z NOR2_X1
.ENDS

.SUBCKT OAI22_X1 A B C D Z
X1 A B int1 OR2_X1
X2 C D int2 OR2_X1
X3 int1 int2 Z NAND2_X1
.ENDS

.SUBCKT AOI211_X1 A B C D Z
X1 A B int1 AND2_X1
X2 int1 C D Z NOR3_X1
.ENDS

.SUBCKT OAI211_X1 A B C D Z
X1 A B int1 OR2_X1
X2 int1 C D Z NAND3_X1
.ENDS

.SUBCKT OAI33_X1 A B C D E F Z
X1 A B C int1 OR3_X1
X2 D E F int2 OR3_X1
X3 int1 int2 Z NAND2_X1
.ENDS

.SUBCKT AOI33_X1 A B C D E F Z
X1 A B C int1 AND3_X1
X2 D E F int2 AND3_X1
X3 int1 int2 Z NOR2_X1
.ENDS

.SUBCKT MUX2_X1 A B S Z
X1 S S_bar INV_X1
X2 A S_bar int1 AND2_X1
X3 B S int2 AND2_X1
X4 int1 int2 Z OR2_X1
.ENDS

.SUBCKT DFF_X1 D C Q QN
X1 D Q_int INV_X1
X2 Q_int Q INV_X1
X3 Q_int QN INV_X1
.ENDS

.SUBCKT DFFR_X1 D C RN Q QN
X1 D Q_int INV_X1
X2 Q_int Q INV_X1
X3 Q_int QN INV_X1
.ENDS

.SUBCKT DFFS_X1 C D Q QN SN
X1 D Q_int INV_X1
X2 Q_int Q INV_X1
X3 Q_int QN INV_X1
.ENDS

.SUBCKT DFFRS_X1 C D Q QN RN SN
X1 D Q_int INV_X1
X2 Q_int Q INV_X1
X3 Q_int QN INV_X1
.ENDS

* Provide VDD power source explicitly
Vvdd 1 0 1.8

* Auto-extracted Inputs:
V_N1 N1 0 1.8
V_N2 N2 0 0.0
V_N3 N3 0 1.8
V_N4 N4 0 0.0
V_N5 N5 0 1.8
V_N6 N6 0 0.0
V_N7 N7 0 1.8
V_N8 N8 0 0.0
V_N11 N11 0 1.8
V_N14 N14 0 0.0
V_N15 N15 0 1.8
V_N16 N16 0 0.0
V_N19 N19 0 1.8
V_N20 N20 0 0.0
V_N21 N21 0 1.8
V_N22 N22 0 0.0
V_N23 N23 0 1.8
V_N24 N24 0 0.0
V_N25 N25 0 1.8
V_N26 N26 0 0.0
V_N27 N27 0 1.8
V_N28 N28 0 0.0
V_N29 N29 0 1.8
V_N32 N32 0 0.0
V_N33 N33 0 1.8
V_N34 N34 0 0.0
V_N35 N35 0 1.8
V_N36 N36 0 0.0
V_N37 N37 0 1.8
V_N40 N40 0 0.0
V_N43 N43 0 1.8
V_N44 N44 0 0.0
V_N47 N47 0 1.8
V_N48 N48 0 0.0
V_N49 N49 0 1.8
V_N50 N50 0 0.0
V_N51 N51 0 1.8
V_N52 N52 0 0.0
V_N53 N53 0 1.8
V_N54 N54 0 0.0
V_N55 N55 0 1.8
V_N56 N56 0 0.0
V_N57 N57 0 1.8
V_N60 N60 0 0.0
V_N61 N61 0 1.8
V_N62 N62 0 0.0
V_N63 N63 0 1.8
V_N64 N64 0 0.0
V_N65 N65 0 1.8
V_N66 N66 0 0.0
V_N67 N67 0 1.8
V_N68 N68 0 0.0
V_N69 N69 0 1.8
V_N72 N72 0 0.0
V_N73 N73 0 1.8
V_N74 N74 0 0.0
V_N75 N75 0 1.8
V_N76 N76 0 0.0
V_N77 N77 0 1.8
V_N78 N78 0 0.0
V_N79 N79 0 1.8
V_N80 N80 0 0.0
V_N81 N81 0 1.8
V_N82 N82 0 0.0
V_N85 N85 0 1.8
V_N86 N86 0 0.0
V_N87 N87 0 1.8
V_N88 N88 0 0.0
V_N89 N89 0 1.8
V_N90 N90 0 0.0
V_N91 N91 0 1.8
V_N92 N92 0 0.0
V_N93 N93 0 1.8
V_N94 N94 0 0.0
V_N95 N95 0 1.8
V_N96 N96 0 0.0
V_N99 N99 0 1.8
V_N100 N100 0 0.0
V_N101 N101 0 1.8
V_N102 N102 0 0.0
V_N103 N103 0 1.8
V_N104 N104 0 0.0
V_N105 N105 0 1.8
V_N106 N106 0 0.0
V_N107 N107 0 1.8
V_N108 N108 0 0.0
V_N111 N111 0 1.8
V_N112 N112 0 0.0
V_N113 N113 0 1.8
V_N114 N114 0 0.0
V_N115 N115 0 1.8
V_N116 N116 0 0.0
V_N117 N117 0 1.8
V_N118 N118 0 0.0
V_N119 N119 0 1.8
V_N120 N120 0 0.0
V_N123 N123 0 1.8
V_N124 N124 0 0.0
V_N125 N125 0 1.8
V_N126 N126 0 0.0
V_N127 N127 0 1.8
V_N128 N128 0 0.0
V_N129 N129 0 1.8
V_N130 N130 0 0.0
V_N131 N131 0 1.8
V_N132 N132 0 0.0
V_N135 N135 0 1.8
V_N136 N136 0 0.0
V_N137 N137 0 1.8
V_N138 N138 0 0.0
V_N139 N139 0 1.8
V_N140 N140 0 0.0
V_N141 N141 0 1.8
V_N142 N142 0 0.0
V_N219 N219 0 1.8
V_N224 N224 0 0.0
V_N227 N227 0 1.8
V_N230 N230 0 0.0
V_N231 N231 0 1.8
V_N234 N234 0 0.0
V_N237 N237 0 1.8
V_N241 N241 0 0.0
V_N246 N246 0 1.8
V_N253 N253 0 0.0
V_N256 N256 0 1.8
V_N259 N259 0 0.0
V_N262 N262 0 1.8
V_N263 N263 0 0.0
V_N266 N266 0 1.8
V_N269 N269 0 0.0
V_N272 N272 0 1.8
V_N275 N275 0 0.0
V_N278 N278 0 1.8
V_N281 N281 0 0.0
V_N284 N284 0 1.8
V_N287 N287 0 0.0
V_N290 N290 0 1.8
V_N294 N294 0 0.0
V_N297 N297 0 1.8
V_N301 N301 0 0.0
V_N305 N305 0 1.8
V_N309 N309 0 0.0
V_N313 N313 0 1.8
V_N316 N316 0 0.0
V_N319 N319 0 1.8
V_N322 N322 0 0.0
V_N325 N325 0 1.8
V_N328 N328 0 0.0
V_N331 N331 0 1.8
V_N334 N334 0 0.0
V_N337 N337 0 1.8
V_N340 N340 0 0.0
V_N343 N343 0 1.8
V_N346 N346 0 0.0
V_N349 N349 0 1.8
V_N352 N352 0 0.0
V_N355 N355 0 1.8
V_N143_I N143_I 0 0.0
V_N144_I N144_I 0 1.8
V_N145_I N145_I 0 0.0
V_N146_I N146_I 0 1.8
V_N147_I N147_I 0 0.0
V_N148_I N148_I 0 1.8
V_N149_I N149_I 0 0.0
V_N150_I N150_I 0 1.8
V_N151_I N151_I 0 0.0
V_N152_I N152_I 0 1.8
V_N153_I N153_I 0 0.0
V_N154_I N154_I 0 1.8
V_N155_I N155_I 0 0.0
V_N156_I N156_I 0 1.8
V_N157_I N157_I 0 0.0
V_N158_I N158_I 0 1.8
V_N159_I N159_I 0 0.0
V_N160_I N160_I 0 1.8
V_N161_I N161_I 0 0.0
V_N162_I N162_I 0 1.8
V_N163_I N163_I 0 0.0
V_N164_I N164_I 0 1.8
V_N165_I N165_I 0 0.0
V_N166_I N166_I 0 1.8
V_N167_I N167_I 0 0.0
V_N168_I N168_I 0 1.8
V_N169_I N169_I 0 0.0
V_N170_I N170_I 0 1.8
V_N171_I N171_I 0 0.0
V_N172_I N172_I 0 1.8
V_N173_I N173_I 0 0.0
V_N174_I N174_I 0 1.8
V_N175_I N175_I 0 0.0
V_N176_I N176_I 0 1.8
V_N177_I N177_I 0 0.0
V_N178_I N178_I 0 1.8
V_N179_I N179_I 0 0.0
V_N180_I N180_I 0 1.8
V_N181_I N181_I 0 0.0
V_N182_I N182_I 0 1.8
V_N183_I N183_I 0 0.0
V_N184_I N184_I 0 1.8
V_N185_I N185_I 0 0.0
V_N186_I N186_I 0 1.8
V_N187_I N187_I 0 0.0
V_N188_I N188_I 0 1.8
V_N189_I N189_I 0 0.0
V_N190_I N190_I 0 1.8
V_N191_I N191_I 0 0.0
V_N192_I N192_I 0 1.8
V_N193_I N193_I 0 0.0
V_N194_I N194_I 0 1.8
V_N195_I N195_I 0 0.0
V_N196_I N196_I 0 1.8
V_N197_I N197_I 0 0.0
V_N198_I N198_I 0 1.8
V_N199_I N199_I 0 0.0
V_N200_I N200_I 0 1.8
V_N201_I N201_I 0 0.0
V_N202_I N202_I 0 1.8
V_N203_I N203_I 0 0.0
V_N204_I N204_I 0 1.8
V_N205_I N205_I 0 0.0
V_N206_I N206_I 0 1.8
V_N207_I N207_I 0 0.0
V_N208_I N208_I 0 1.8
V_N209_I N209_I 0 0.0
V_N210_I N210_I 0 1.8
V_N211_I N211_I 0 0.0
V_N212_I N212_I 0 1.8
V_N213_I N213_I 0 0.0
V_N214_I N214_I 0 1.8
V_N215_I N215_I 0 0.0
V_N216_I N216_I 0 1.8
V_N217_I N217_I 0 0.0
V_N218_I N218_I 0 1.8

* Yosys Generated Netlist:
* SPICE netlist generated by Yosys 0.62 (git sha1 7326bb7d6641500ecb285c291a54a662cb1e76cf, clang++ 17.0.0 -fPIC -O3)

X0 N132 N488 INV_X1
X1 N82 N489 INV_X1
X2 N96 N490 INV_X1
X3 N44 N487 INV_X1
X4 N120 N492 INV_X1
X5 N57 N493 INV_X1
X6 N108 N494 INV_X1
X7 N69 N491 INV_X1
X8 N227 1 INV_X1
X9 N234 2 INV_X1
X10 N74 3 INV_X1
X11 N259 4 INV_X1
X12 N287 5 INV_X1
X13 N40 6 INV_X1
X14 N262 7 INV_X1
X15 N37 8 INV_X1
X16 N94 N219 N1026 AND2_X1
X17 N120 N57 N108 N69 9 NAND4_X1
X18 N132 N82 N96 N44 10 NAND4_X1
X19 9 10 N1448 OR2_X1
X20 N1448 N1277 INV_X1
X21 N231 9 10 N325 N1726 AOI22_X1
X22 N227 N53 11 AND2_X1
X23 11 N91 1 12 AOI21_X1
X24 N227 2 13 NOR2_X1
X25 1 2 14 NOR2_X1
X26 N65 13 14 N78 15 AOI22_X1
X27 15 12 N234 N2010 OAI21_X1
X28 N90 N52 N227 16 MUX2_X1
X29 16 17 INV_X1
X30 N64 13 14 N77 18 AOI22_X1
X31 18 17 N234 N2012 OAI21_X1
X32 N2012 N1821 INV_X1
X33 N89 N51 N227 19 MUX2_X1
X34 19 20 INV_X1
X35 N63 13 14 N76 21 AOI22_X1
X36 21 20 N234 N2014 OAI21_X1
X37 N2014 N1820 INV_X1
X38 N88 N50 N227 22 MUX2_X1
X39 22 23 INV_X1
X40 N62 13 14 N75 24 AOI22_X1
X41 24 23 N234 N2016 OAI21_X1
X42 N2016 N1819 INV_X1
X43 1 N87 25 NAND2_X1
X44 N234 N49 N227 26 AOI21_X1
X45 3 14 25 26 N2018 AOI22_X1
X46 N86 N48 N227 27 MUX2_X1
X47 27 28 INV_X1
X48 N61 13 14 N73 29 AOI22_X1
X49 29 28 N234 N2020 OAI21_X1
X50 N227 N47 30 AND2_X1
X51 30 N85 1 31 AOI21_X1
X52 N60 13 14 N72 32 AOI22_X1
X53 32 31 N234 N2022 OAI21_X1
X54 N81 N43 N227 33 MUX2_X1
X55 33 34 INV_X1
X56 N56 13 14 N68 35 AOI22_X1
X57 35 34 N234 36 OAI21_X1
X58 N241 35 34 N234 N1969 OAI211_X1
X59 N125 N113 N319 37 MUX2_X1
X60 N137 N101 N319 38 MUX2_X1
X61 38 37 N322 39 MUX2_X1
X62 39 N1816 INV_X1
X63 N227 N92 40 OR2_X1
X64 2 40 N54 1 41 OAI211_X1
X65 N66 13 14 N79 42 AOI22_X1
X66 41 42 43 AND2_X1
X67 41 42 44 NAND2_X1
X68 44 N2012 N246 N2387 MUX2_X1
X69 N2010 N2014 N246 N2389 MUX2_X1
X70 N126 N114 N319 45 MUX2_X1
X71 N138 N102 N319 46 MUX2_X1
X72 46 45 N322 47 MUX2_X1
X73 47 N1818 INV_X1
X74 N124 N112 N319 48 MUX2_X1
X75 N136 N100 N319 49 MUX2_X1
X76 49 48 N322 50 MUX2_X1
X77 50 N1817 INV_X1
X78 N230 44 51 NOR2_X1
X79 51 43 N241 N2496 AOI21_X1
X80 N246 36 52 NOR2_X1
X81 52 51 N246 N2643 AOI21_X1
X82 N256 N259 53 XOR2_X1
X83 N349 N346 54 XNOR2_X1
X84 53 54 55 XNOR2_X1
X85 N343 N340 56 XOR2_X1
X86 N337 N334 57 XNOR2_X1
X87 56 57 58 XNOR2_X1
X88 N331 N328 59 XOR2_X1
X89 58 59 60 XNOR2_X1
X90 N14 55 60 61 OAI21_X1
X91 61 60 55 N2925 AOI21_X1
X92 N266 N269 62 XOR2_X1
X93 N284 N287 63 XOR2_X1
X94 62 63 64 XNOR2_X1
X95 N278 N281 65 XNOR2_X1
X96 N272 N275 66 XNOR2_X1
X97 65 66 67 XNOR2_X1
X98 N263 N352 68 XNOR2_X1
X99 67 68 69 XNOR2_X1
X100 64 69 N2971 XNOR2_X1
X101 N309 N305 70 XNOR2_X1
X102 N301 N297 71 XOR2_X1
X103 70 71 72 XNOR2_X1
X104 N313 N316 73 XNOR2_X1
X105 N294 N355 74 XNOR2_X1
X106 73 74 75 XNOR2_X1
X107 72 75 76 XNOR2_X1
X108 76 N2970 INV_X1
X109 N6 N2020 N16 77 MUX2_X1
X110 N278 77 78 NAND2_X1
X111 N16 43 79 NAND2_X1
X112 79 N16 N4 80 OAI21_X1
X113 N119 N107 N319 81 MUX2_X1
X114 N131 N95 N319 82 MUX2_X1
X115 82 81 N322 83 MUX2_X1
X116 N25 83 N29 84 MUX2_X1
X117 4 80 84 N284 85 AOI22_X1
X118 N129 N117 N319 86 MUX2_X1
X119 N141 N105 N319 87 MUX2_X1
X120 87 86 N322 88 MUX2_X1
X121 N32 88 N29 89 MUX2_X1
X122 N34 39 N29 90 MUX2_X1
X123 N305 90 91 NAND2_X1
X124 91 89 N287 92 OAI21_X1
X125 N24 N2022 N16 93 MUX2_X1
X126 N281 93 94 XNOR2_X1
X127 N20 N2010 N16 95 MUX2_X1
X128 N263 95 96 XNOR2_X1
X129 N127 N115 N319 97 MUX2_X1
X130 N139 N103 N319 98 MUX2_X1
X131 98 97 N322 99 MUX2_X1
X132 N33 99 N29 100 MUX2_X1
X133 N287 89 101 NAND2_X1
X134 101 100 N297 102 OAI21_X1
X135 92 94 96 102 103 NOR4_X1
X136 N128 N116 N319 104 MUX2_X1
X137 N140 N104 N319 105 MUX2_X1
X138 105 104 N322 106 MUX2_X1
X139 N26 106 N29 107 MUX2_X1
X140 N294 107 108 XNOR2_X1
X141 N22 N2016 N16 109 MUX2_X1
X142 N272 109 110 XNOR2_X1
X143 N5 N2012 N16 111 MUX2_X1
X144 N123 N111 N319 112 MUX2_X1
X145 N135 N99 N319 113 MUX2_X1
X146 113 112 N322 114 MUX2_X1
X147 N28 114 N29 115 MUX2_X1
X148 N11 115 111 N266 116 OAI211_X1
X149 N27 47 N29 117 MUX2_X1
X150 N301 117 118 NAND2_X1
X151 N23 N2018 N16 119 MUX2_X1
X152 N21 N2014 N16 120 MUX2_X1
X153 N275 119 120 N269 121 AOI22_X1
X154 118 121 N284 84 122 OAI211_X1
X155 N35 50 N29 123 MUX2_X1
X156 N309 123 124 NAND2_X1
X157 N309 123 125 NOR2_X1
X158 125 111 N266 126 AOI21_X1
X159 124 126 N278 77 127 OAI211_X1
X160 N19 36 N16 128 MUX2_X1
X161 N256 128 129 XOR2_X1
X162 129 119 N275 N301 117 130 OAI221_X1
X163 N305 90 131 NOR2_X1
X164 131 100 N297 132 AOI21_X1
X165 132 80 4 N269 120 133 OAI221_X1
X166 122 127 130 133 134 OR4_X1
X167 108 110 116 134 135 NOR4_X1
X168 78 85 103 135 N3038 AND4_X1
X169 78 85 103 135 N3079 NAND4_X1
X170 N227 N55 136 AND2_X1
X171 136 N93 1 137 AOI21_X1
X172 N67 13 14 N80 138 AOI22_X1
X173 138 137 N234 139 OAI21_X1
X174 N230 43 140 NAND2_X1
X175 36 139 141 XOR2_X1
X176 140 141 142 XOR2_X1
X177 142 139 N241 N3546 MUX2_X1
X178 88 106 143 XNOR2_X1
X179 N130 N118 N319 144 MUX2_X1
X180 N142 N106 N319 145 MUX2_X1
X181 145 144 N322 146 MUX2_X1
X182 83 146 147 XNOR2_X1
X183 47 99 148 XNOR2_X1
X184 143 148 149 XNOR2_X1
X185 147 149 150 XNOR2_X1
X186 50 114 151 XOR2_X1
X187 39 151 152 XNOR2_X1
X188 8 150 152 153 OAI21_X1
X189 153 152 150 N3671 AOI21_X1
X190 N2020 N2022 154 XOR2_X1
X191 N2016 N2018 155 XNOR2_X1
X192 154 155 156 XNOR2_X1
X193 N2010 43 157 XNOR2_X1
X194 141 157 158 XNOR2_X1
X195 156 158 159 XNOR2_X1
X196 51 159 160 XNOR2_X1
X197 139 160 N246 N3803 MUX2_X1
X198 N2012 N2014 161 XNOR2_X1
X199 8 159 161 162 OAI21_X1
X200 162 161 159 N3809 AOI21_X1
X201 6 39 163 NOR2_X1
X202 7 47 163 164 NAND3_X1
X203 N294 N259 164 165 MUX2_X1
X204 N256 164 166 AND2_X1
X205 35 164 5 34 N234 167 OAI221_X1
X206 44 165 166 167 168 OAI22_X1
X207 N297 N263 164 169 MUX2_X1
X208 44 165 169 N2010 170 AOI22_X1
X209 N301 N266 164 171 MUX2_X1
X210 N2010 169 171 N2012 172 OAI22_X1
X211 172 170 168 173 AOI21_X1
X212 N2012 171 174 NAND2_X1
X213 N305 N269 164 175 MUX2_X1
X214 N8 N2014 175 176 NAND3_X1
X215 174 176 177 NAND2_X1
X216 N309 N272 164 178 MUX2_X1
X217 N2014 175 178 N2016 179 OAI22_X1
X218 N8 179 180 NAND2_X1
X219 180 177 173 181 OAI21_X1
X220 N8 N2016 178 182 NAND3_X1
X221 N8 164 183 AND2_X1
X222 N275 N2018 183 184 NAND3_X1
X223 182 184 185 AND2_X1
X224 N275 N2018 N2020 N278 186 OAI22_X1
X225 181 185 186 183 187 AOI22_X1
X226 N278 N2020 183 188 NAND3_X1
X227 163 N1818 N262 189 OAI21_X1
X228 N281 N2022 189 190 NOR3_X1
X229 N287 88 189 191 NOR3_X1
X230 190 191 192 NOR2_X1
X231 N294 106 189 193 OR3_X1
X232 N287 88 106 N294 194 AOI22_X1
X233 193 194 189 195 OAI21_X1
X234 N284 83 196 OR2_X1
X235 N284 83 197 NAND2_X1
X236 N281 N2022 83 N284 198 AOI22_X1
X237 189 196 198 199 AOI21_X1
X238 195 199 200 NOR2_X1
X239 188 192 200 201 NAND3_X1
X240 189 196 202 NOR2_X1
X241 191 202 197 190 203 AOI211_X1
X242 193 195 203 201 187 N3851 OAI221_X1
X243 N2925 N2971 204 NOR2_X1
X244 N1726 76 204 205 NAND3_X1
X245 N3671 N3809 205 N3881 NOR3_X1
X246 N3671 N3809 205 N3882 OR3_X1
X247 N237 N7 N1028 NAND2_X1
X248 N237 N7 N231 N1029 NAND3_X1
X249 N313 114 206 XNOR2_X1
X250 N316 206 N2891 OR2_X1
X251 N309 N305 N301 N297 N792 NAND4_X1
X252 N2 N15 N237 N799 NAND3_X1
X253 N237 N7 N325 N1269 NAND3_X1
X254 N237 N36 N224 N1726 N1970 NAND4_X1
X255 N1 N3 207 NAND2_X1
X256 N237 N224 N1726 207 N1971 NAND4_X1
V0 N2018 N2695 DC 0
V1 N2016 N2696 DC 0
V2 N2022 N2697 DC 0
V3 N2020 N2698 DC 0
V4 N2018 N2699 DC 0
V5 N2016 N2700 DC 0
V6 N2022 N2701 DC 0
V7 N2020 N2702 DC 0
V8 Vss N2709 DC 0
V9 Vss N2710 DC 0
V10 N1819 N2443 DC 0
V11 N1821 N2437 DC 0
V12 N2925 N2817 DC 0
V13 N3038 N2931 DC 0
V14 N2389 N2390 DC 0
V15 N153_I N153_O DC 0
V16 N2387 N2388 DC 0
V17 N2010 N2617 DC 0
V18 N2014 N2367 DC 0
V19 N2012 N2620 DC 0
V20 N143_I N143_O DC 0
V21 N154_I N154_O DC 0
V22 N8 N1190 DC 0
V23 N144_I N144_O DC 0
V24 N155_I N155_O DC 0
V25 N8 N1195 DC 0
V26 N8 N1070 DC 0
V27 N156_I N156_O DC 0
V28 N287 N1572 DC 0
V29 N294 N1573 DC 0
V30 N297 N1574 DC 0
V31 N301 N1575 DC 0
V32 N305 N1576 DC 0
V33 N309 N1577 DC 0
V34 N157_I N157_O DC 0
V35 N145_I N145_O DC 0
V36 N158_I N158_O DC 0
V37 N1726 N1591 DC 0
V38 N159_I N159_O DC 0
V39 N160_I N160_O DC 0
V40 N2010 N1612 DC 0
V41 N2012 N1615 DC 0
V42 N2014 N1619 DC 0
V43 N161_I N161_O DC 0
V44 N2016 N1624 DC 0
V45 N2389 N2269 DC 0
V46 N2387 N2266 DC 0
V47 N2018 N1628 DC 0
V48 N162_I N162_O DC 0
V49 N2020 N1631 DC 0
V50 N2022 N1634 DC 0
V51 N1816 N2235 DC 0
V52 N1817 N2234 DC 0
V53 N2010 N2628 DC 0
V54 N2010 N2630 DC 0
V55 N1821 N2481 DC 0
V56 N1820 N2194 DC 0
V57 N218_I N218_O DC 0
V58 N1821 N2475 DC 0
V59 N163_I N163_O DC 0
V60 N2643 N2521 DC 0
V61 N217_I N217_O DC 0
V62 N164_I N164_O DC 0
V63 N1818 N2175 DC 0
V64 N216_I N216_O DC 0
V65 N215_I N215_O DC 0
V66 N165_I N165_O DC 0
V67 N166_I N166_O DC 0
V68 N167_I N167_O DC 0
V69 N146_I N146_O DC 0
V70 N168_I N168_O DC 0
V71 N169_I N169_O DC 0
V72 N170_I N170_O DC 0
V73 N214_I N214_O DC 0
V74 N1819 N2141 DC 0
V75 N213_I N213_O DC 0
V76 N1821 N2135 DC 0
V77 N212_I N212_O DC 0
V78 N211_I N211_O DC 0
V79 N171_I N171_O DC 0
V80 N210_I N210_O DC 0
V81 N172_I N172_O DC 0
V82 N173_I N173_O DC 0
V83 N174_I N174_O DC 0
V84 N175_I N175_O DC 0
V85 N209_I N209_O DC 0
V86 N208_I N208_O DC 0
V87 N207_I N207_O DC 0
V88 N176_I N176_O DC 0
V89 N1277 N1034 DC 0
V90 N8 N1037 DC 0
V91 N206_I N206_O DC 0
V92 N177_I N177_O DC 0
V93 N3671 N3600 DC 0
V94 N178_I N178_O DC 0
V95 N205_I N205_O DC 0
V96 N204_I N204_O DC 0
V97 N179_I N179_O DC 0
V98 N203_I N203_O DC 0
V99 N147_I N147_O DC 0
V100 N180_I N180_O DC 0
V101 N152_I N152_O DC 0
V102 N284 N1528 DC 0
V103 N202_I N202_O DC 0
V104 N281 N1527 DC 0
V105 N181_I N181_O DC 0
V106 N201_I N201_O DC 0
V107 N200_I N200_O DC 0
V108 N182_I N182_O DC 0
V109 N199_I N199_O DC 0
V110 N198_I N198_O DC 0
V111 N148_I N148_O DC 0
V112 N3803 N3780 DC 0
V113 N3809 N3790 DC 0
V114 N197_I N197_O DC 0
V115 N3803 N3804 DC 0
V116 N183_I N183_O DC 0
V117 N196_I N196_O DC 0
V118 N2010 N1848 DC 0
V119 N184_I N184_O DC 0
V120 N2012 N1852 DC 0
V121 N2643 N2644 DC 0
V122 N2012 N2645 DC 0
V123 N195_I N195_O DC 0
V124 N2014 N1856 DC 0
V125 N185_I N185_O DC 0
V126 N2016 N1863 DC 0
V127 N2010 N2655 DC 0
V128 N2012 N2656 DC 0
V129 N3851 N3840 DC 0
V130 N3851 N3843 DC 0
V131 Vss N3857 DC 0
V132 Vss N3858 DC 0
V133 Vss N3859 DC 0
V134 Vdd N3864 DC 0
V135 Vss N3869 DC 0
V136 Vdd N3870 DC 0
V137 Vss N3875 DC 0
V138 N186_I N186_O DC 0
V139 N3881 N3877 DC 0
V140 N219 N398 DC 0
V141 N219 N400 DC 0
V142 N219 N401 DC 0
V143 N2018 N1870 DC 0
V144 N2020 N1875 DC 0
V145 N253 N419 DC 0
V146 N253 N420 DC 0
V147 N290 N456 DC 0
V148 N290 N457 DC 0
V149 N290 N458 DC 0
V150 N187_I N187_O DC 0
V151 N2022 N1880 DC 0
V152 N237 N496 DC 0
V153 N37 N499 DC 0
V154 N219 N500 DC 0
V155 N8 N503 DC 0
V156 N8 N506 DC 0
V157 N227 N509 DC 0
V158 N234 N521 DC 0
V159 N188_I N188_O DC 0
V160 N194_I N194_O DC 0
V161 N227 N550 DC 0
V162 N234 N562 DC 0
V163 N1819 N2460 DC 0
V164 N319 N582 DC 0
V165 N322 N594 DC 0
V166 N1816 N1897 DC 0
V167 N189_I N189_O DC 0
V168 N319 N613 DC 0
V169 N322 N625 DC 0
V170 N16 N637 DC 0
V171 N16 N643 DC 0
V172 N190_I N190_O DC 0
V173 N278 N1526 DC 0
V174 N275 N1525 DC 0
V175 N193_I N193_O DC 0
V176 N272 N1524 DC 0
V177 N269 N1523 DC 0
V178 N266 N1522 DC 0
V179 N29 N693 DC 0
V180 N29 N699 DC 0
V181 N263 N1521 DC 0
V182 N259 N1520 DC 0
V183 N151_I N151_O DC 0
V184 N192_I N192_O DC 0
V185 N256 N1519 DC 0
V186 N149_I N149_O DC 0
V187 N259 N735 DC 0
V188 N256 N738 DC 0
V189 N263 N741 DC 0
V190 N269 N744 DC 0
V191 N266 N747 DC 0
V192 N275 N750 DC 0
V193 N272 N753 DC 0
V194 N281 N756 DC 0
V195 N278 N759 DC 0
V196 N287 N762 DC 0
V197 N284 N765 DC 0
V198 N294 N768 DC 0
V199 N301 N771 DC 0
V200 N297 N774 DC 0
V201 N309 N777 DC 0
V202 N305 N780 DC 0
V203 N316 N783 DC 0
V204 N313 N786 DC 0
V205 N219 N805 DC 0
V206 N150_I N150_O DC 0
V207 N191_I N191_O DC 0

************************
* end of SPICE netlist *
************************

* Anti-Floating Pull-Downs (GMIN)
R_PD_0 96 0 100meg
R_PD_1 177 0 100meg
R_PD_2 187 0 100meg
R_PD_3 N2022 0 100meg
R_PD_4 N137 0 100meg
R_PD_5 157 0 100meg
R_PD_6 N2496 0 100meg
R_PD_7 117 0 100meg
R_PD_8 38 0 100meg
R_PD_9 N14 0 100meg
R_PD_10 N116 0 100meg
R_PD_11 109 0 100meg
R_PD_12 N48 0 100meg
R_PD_13 72 0 100meg
R_PD_14 N2014 0 100meg
R_PD_15 161 0 100meg
R_PD_16 76 0 100meg
R_PD_17 N334 0 100meg
R_PD_18 N1277 0 100meg
R_PD_19 200 0 100meg
R_PD_20 N136 0 100meg
R_PD_21 N234 0 100meg
R_PD_22 N1819 0 100meg
R_PD_23 N256 0 100meg
R_PD_24 102 0 100meg
R_PD_25 N491 0 100meg
R_PD_26 52 0 100meg
R_PD_27 127 0 100meg
R_PD_28 43 0 100meg
R_PD_29 135 0 100meg
R_PD_30 N35 0 100meg
R_PD_31 N487 0 100meg
R_PD_32 N29 0 100meg
R_PD_33 61 0 100meg
R_PD_34 48 0 100meg
R_PD_35 106 0 100meg
R_PD_36 58 0 100meg
R_PD_37 N6 0 100meg
R_PD_38 N3809 0 100meg
R_PD_39 10 0 100meg
R_PD_40 N100 0 100meg
R_PD_41 56 0 100meg
R_PD_42 68 0 100meg
R_PD_43 37 0 100meg
R_PD_44 134 0 100meg
R_PD_45 3 0 100meg
R_PD_46 20 0 100meg
R_PD_47 N125 0 100meg
R_PD_48 N1969 0 100meg
R_PD_49 N20 0 100meg
R_PD_50 N2016 0 100meg
R_PD_51 N60 0 100meg
R_PD_52 N82 0 100meg
R_PD_53 165 0 100meg
R_PD_54 180 0 100meg
R_PD_55 N107 0 100meg
R_PD_56 142 0 100meg
R_PD_57 151 0 100meg
R_PD_58 N79 0 100meg
R_PD_59 17 0 100meg
R_PD_60 166 0 100meg
R_PD_61 36 0 100meg
R_PD_62 N77 0 100meg
R_PD_63 N266 0 100meg
R_PD_64 138 0 100meg
R_PD_65 202 0 100meg
R_PD_66 N23 0 100meg
R_PD_67 N89 0 100meg
R_PD_68 N37 0 100meg
R_PD_69 N3882 0 100meg
R_PD_70 53 0 100meg
R_PD_71 59 0 100meg
R_PD_72 N139 0 100meg
R_PD_73 N102 0 100meg
R_PD_74 113 0 100meg
R_PD_75 N106 0 100meg
R_PD_76 128 0 100meg
R_PD_77 N94 0 100meg
R_PD_78 N346 0 100meg
R_PD_79 125 0 100meg
R_PD_80 N114 0 100meg
R_PD_81 92 0 100meg
R_PD_82 22 0 100meg
R_PD_83 N74 0 100meg
R_PD_84 44 0 100meg
R_PD_85 71 0 100meg
R_PD_86 41 0 100meg
R_PD_87 N128 0 100meg
R_PD_88 130 0 100meg
R_PD_89 152 0 100meg
R_PD_90 104 0 100meg
R_PD_91 N51 0 100meg
R_PD_92 N284 0 100meg
R_PD_93 N129 0 100meg
R_PD_94 111 0 100meg
R_PD_95 31 0 100meg
R_PD_96 N230 0 100meg
R_PD_97 159 0 100meg
R_PD_98 N3803 0 100meg
R_PD_99 27 0 100meg
R_PD_100 78 0 100meg
R_PD_101 13 0 100meg
R_PD_102 178 0 100meg
R_PD_103 N1448 0 100meg
R_PD_104 N32 0 100meg
R_PD_105 162 0 100meg
R_PD_106 N63 0 100meg
R_PD_107 N294 0 100meg
R_PD_108 N130 0 100meg
R_PD_109 21 0 100meg
R_PD_110 N2891 0 100meg
R_PD_111 N488 0 100meg
R_PD_112 N281 0 100meg
R_PD_113 169 0 100meg
R_PD_114 N140 0 100meg
R_PD_115 N4 0 100meg
R_PD_116 65 0 100meg
R_PD_117 N53 0 100meg
R_PD_118 N343 0 100meg
R_PD_119 N3079 0 100meg
R_PD_120 87 0 100meg
R_PD_121 N1970 0 100meg
R_PD_122 N325 0 100meg
R_PD_123 136 0 100meg
R_PD_124 N72 0 100meg
R_PD_125 N1269 0 100meg
R_PD_126 N115 0 100meg
R_PD_127 N92 0 100meg
R_PD_128 66 0 100meg
R_PD_129 51 0 100meg
R_PD_130 26 0 100meg
R_PD_131 N1820 0 100meg
R_PD_132 107 0 100meg
R_PD_133 1 0 100meg
R_PD_134 100 0 100meg
R_PD_135 116 0 100meg
R_PD_136 N297 0 100meg
R_PD_137 N269 0 100meg
R_PD_138 N120 0 100meg
R_PD_139 N1029 0 100meg
R_PD_140 N123 0 100meg
R_PD_141 144 0 100meg
R_PD_142 89 0 100meg
R_PD_143 153 0 100meg
R_PD_144 N7 0 100meg
R_PD_145 121 0 100meg
R_PD_146 149 0 100meg
R_PD_147 97 0 100meg
R_PD_148 N246 0 100meg
R_PD_149 15 0 100meg
R_PD_150 4 0 100meg
R_PD_151 N1 0 100meg
R_PD_152 N90 0 100meg
R_PD_153 201 0 100meg
R_PD_154 N85 0 100meg
R_PD_155 7 0 100meg
R_PD_156 207 0 100meg
R_PD_157 150 0 100meg
R_PD_158 N64 0 100meg
R_PD_159 N124 0 100meg
R_PD_160 N75 0 100meg
R_PD_161 N61 0 100meg
R_PD_162 N355 0 100meg
R_PD_163 192 0 100meg
R_PD_164 N66 0 100meg
R_PD_165 34 0 100meg
R_PD_166 N3038 0 100meg
R_PD_167 N2012 0 100meg
R_PD_168 N340 0 100meg
R_PD_169 N40 0 100meg
R_PD_170 N104 0 100meg
R_PD_171 N44 0 100meg
R_PD_172 172 0 100meg
R_PD_173 N16 0 100meg
R_PD_174 190 0 100meg
R_PD_175 88 0 100meg
R_PD_176 N86 0 100meg
R_PD_177 93 0 100meg
R_PD_178 N118 0 100meg
R_PD_179 N68 0 100meg
R_PD_180 32 0 100meg
R_PD_181 N301 0 100meg
R_PD_182 N263 0 100meg
R_PD_183 182 0 100meg
R_PD_184 14 0 100meg
R_PD_185 N1028 0 100meg
R_PD_186 N305 0 100meg
R_PD_187 175 0 100meg
R_PD_188 N101 0 100meg
R_PD_189 N26 0 100meg
R_PD_190 N27 0 100meg
R_PD_191 84 0 100meg
R_PD_192 185 0 100meg
R_PD_193 N3546 0 100meg
R_PD_194 N799 0 100meg
R_PD_195 191 0 100meg
R_PD_196 N25 0 100meg
R_PD_197 N105 0 100meg
R_PD_198 N492 0 100meg
R_PD_199 N15 0 100meg
R_PD_200 176 0 100meg
R_PD_201 N81 0 100meg
R_PD_202 N1818 0 100meg
R_PD_203 N1026 0 100meg
R_PD_204 N231 0 100meg
R_PD_205 194 0 100meg
R_PD_206 N88 0 100meg
R_PD_207 148 0 100meg
R_PD_208 60 0 100meg
R_PD_209 N1817 0 100meg
R_PD_210 55 0 100meg
R_PD_211 N34 0 100meg
R_PD_212 39 0 100meg
R_PD_213 N493 0 100meg
R_PD_214 18 0 100meg
R_PD_215 179 0 100meg
R_PD_216 N489 0 100meg
R_PD_217 126 0 100meg
R_PD_218 158 0 100meg
R_PD_219 137 0 100meg
R_PD_220 23 0 100meg
R_PD_221 N259 0 100meg
R_PD_222 30 0 100meg
R_PD_223 N142 0 100meg
R_PD_224 167 0 100meg
R_PD_225 132 0 100meg
R_PD_226 N87 0 100meg
R_PD_227 29 0 100meg
R_PD_228 N113 0 100meg
R_PD_229 90 0 100meg
R_PD_230 6 0 100meg
R_PD_231 146 0 100meg
R_PD_232 64 0 100meg
R_PD_233 N93 0 100meg
R_PD_234 73 0 100meg
R_PD_235 164 0 100meg
R_PD_236 N69 0 100meg
R_PD_237 N262 0 100meg
R_PD_238 N3 0 100meg
R_PD_239 N36 0 100meg
R_PD_240 N309 0 100meg
R_PD_241 156 0 100meg
R_PD_242 131 0 100meg
R_PD_243 115 0 100meg
R_PD_244 160 0 100meg
R_PD_245 N55 0 100meg
R_PD_246 186 0 100meg
R_PD_247 N792 0 100meg
R_PD_248 147 0 100meg
R_PD_249 74 0 100meg
R_PD_250 46 0 100meg
R_PD_251 N272 0 100meg
R_PD_252 198 0 100meg
R_PD_253 N331 0 100meg
R_PD_254 170 0 100meg
R_PD_255 173 0 100meg
R_PD_256 N131 0 100meg
R_PD_257 124 0 100meg
R_PD_258 8 0 100meg
R_PD_259 N56 0 100meg
R_PD_260 N337 0 100meg
R_PD_261 99 0 100meg
R_PD_262 N278 0 100meg
R_PD_263 199 0 100meg
R_PD_264 54 0 100meg
R_PD_265 108 0 100meg
R_PD_266 N91 0 100meg
R_PD_267 N2971 0 100meg
R_PD_268 112 0 100meg
R_PD_269 86 0 100meg
R_PD_270 N99 0 100meg
R_PD_271 28 0 100meg
R_PD_272 120 0 100meg
R_PD_273 118 0 100meg
R_PD_274 33 0 100meg
R_PD_275 N78 0 100meg
R_PD_276 98 0 100meg
R_PD_277 94 0 100meg
R_PD_278 171 0 100meg
R_PD_279 155 0 100meg
R_PD_280 N2 0 100meg
R_PD_281 189 0 100meg
R_PD_282 N2020 0 100meg
R_PD_283 N2010 0 100meg
R_PD_284 139 0 100meg
R_PD_285 80 0 100meg
R_PD_286 N95 0 100meg
R_PD_287 45 0 100meg
R_PD_288 N73 0 100meg
R_PD_289 N2389 0 100meg
R_PD_290 N47 0 100meg
R_PD_291 N3881 0 100meg
R_PD_292 N313 0 100meg
R_PD_293 49 0 100meg
R_PD_294 62 0 100meg
R_PD_295 N127 0 100meg
R_PD_296 122 0 100meg
R_PD_297 N50 0 100meg
R_PD_298 205 0 100meg
R_PD_299 N111 0 100meg
R_PD_300 N490 0 100meg
R_PD_301 N287 0 100meg
R_PD_302 203 0 100meg
R_PD_303 143 0 100meg
R_PD_304 67 0 100meg
R_PD_305 N2925 0 100meg
R_PD_306 N319 0 100meg
R_PD_307 5 0 100meg
R_PD_308 N494 0 100meg
R_PD_309 101 0 100meg
R_PD_310 N49 0 100meg
R_PD_311 174 0 100meg
R_PD_312 N76 0 100meg
R_PD_313 N322 0 100meg
R_PD_314 N62 0 100meg
R_PD_315 69 0 100meg
R_PD_316 50 0 100meg
R_PD_317 184 0 100meg
R_PD_318 110 0 100meg
R_PD_319 119 0 100meg
R_PD_320 181 0 100meg
R_PD_321 N224 0 100meg
R_PD_322 24 0 100meg
R_PD_323 57 0 100meg
R_PD_324 N103 0 100meg
R_PD_325 9 0 100meg
R_PD_326 N2387 0 100meg
R_PD_327 N112 0 100meg
R_PD_328 N33 0 100meg
R_PD_329 12 0 100meg
R_PD_330 N1971 0 100meg
R_PD_331 140 0 100meg
R_PD_332 N227 0 100meg
R_PD_333 N328 0 100meg
R_PD_334 103 0 100meg
R_PD_335 N96 0 100meg
R_PD_336 40 0 100meg
R_PD_337 N126 0 100meg
R_PD_338 N2018 0 100meg
R_PD_339 195 0 100meg
R_PD_340 N349 0 100meg
R_PD_341 83 0 100meg
R_PD_342 N237 0 100meg
R_PD_343 N138 0 100meg
R_PD_344 N11 0 100meg
R_PD_345 N19 0 100meg
R_PD_346 N67 0 100meg
R_PD_347 2 0 100meg
R_PD_348 N54 0 100meg
R_PD_349 N119 0 100meg
R_PD_350 N43 0 100meg
R_PD_351 N5 0 100meg
R_PD_352 75 0 100meg
R_PD_353 141 0 100meg
R_PD_354 82 0 100meg
R_PD_355 105 0 100meg
R_PD_356 168 0 100meg
R_PD_357 N57 0 100meg
R_PD_358 N2643 0 100meg
R_PD_359 85 0 100meg
R_PD_360 79 0 100meg
R_PD_361 N24 0 100meg
R_PD_362 154 0 100meg
R_PD_363 N80 0 100meg
R_PD_364 204 0 100meg
R_PD_365 16 0 100meg
R_PD_366 70 0 100meg
R_PD_367 163 0 100meg
R_PD_368 193 0 100meg
R_PD_369 77 0 100meg
R_PD_370 183 0 100meg
R_PD_371 N352 0 100meg
R_PD_372 35 0 100meg
R_PD_373 N132 0 100meg
R_PD_374 N117 0 100meg
R_PD_375 N65 0 100meg
R_PD_376 N52 0 100meg
R_PD_377 114 0 100meg
R_PD_378 145 0 100meg
R_PD_379 188 0 100meg
R_PD_380 206 0 100meg
R_PD_381 N316 0 100meg
R_PD_382 N135 0 100meg
R_PD_383 197 0 100meg
R_PD_384 47 0 100meg
R_PD_385 N2970 0 100meg
R_PD_386 N241 0 100meg
R_PD_387 63 0 100meg
R_PD_388 81 0 100meg
R_PD_389 42 0 100meg
R_PD_390 N108 0 100meg
R_PD_391 N28 0 100meg
R_PD_392 N1821 0 100meg
R_PD_393 123 0 100meg
R_PD_394 25 0 100meg
R_PD_395 N1816 0 100meg
R_PD_396 N22 0 100meg
R_PD_397 196 0 100meg
R_PD_398 N8 0 100meg
R_PD_399 19 0 100meg
R_PD_400 N1726 0 100meg
R_PD_401 N3851 0 100meg
R_PD_402 N219 0 100meg
R_PD_403 N21 0 100meg
R_PD_404 N275 0 100meg
R_PD_405 129 0 100meg
R_PD_406 N3671 0 100meg
R_PD_407 95 0 100meg
R_PD_408 N141 0 100meg
R_PD_409 91 0 100meg
R_PD_410 11 0 100meg
R_PD_411 133 0 100meg

* Transient Simulation Directive
.TRAN 100p 10n
