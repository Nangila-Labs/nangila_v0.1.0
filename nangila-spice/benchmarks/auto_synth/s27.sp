* Nangila SPICE Auto-Synthesized Netlist
.SUBCKT INV_X1 A Z
M1 Z A 0 0 NMOS W=0.2u L=0.05u
M2 Z A 1 1 PMOS W=0.4u L=0.05u
.ENDS

.SUBCKT NAND2_X1 A1 A2 Z
M1 Z A1 1 1 PMOS W=0.4u L=0.05u
M2 Z A2 1 1 PMOS W=0.4u L=0.05u
M3 Z A1 int 0 NMOS W=0.2u L=0.05u
M4 int A2 0 0 NMOS W=0.2u L=0.05u
.ENDS

.SUBCKT AND2_X1 A1 A2 Z
X1 A1 A2 Z_bar NAND2_X1
X2 Z_bar Z INV_X1
.ENDS

.SUBCKT NOR2_X1 A1 A2 Z
M1 int1 A1 1 1 PMOS W=0.4u L=0.05u
M2 Z A2 int1 1 PMOS W=0.4u L=0.05u
M3 Z A1 0 0 NMOS W=0.2u L=0.05u
M4 Z A2 0 0 NMOS W=0.2u L=0.05u
.ENDS

.SUBCKT OR2_X1 A1 A2 Z
X1 A1 A2 Z_bar NOR2_X1
X2 Z_bar Z INV_X1
.ENDS

.SUBCKT XOR2_X1 A1 A2 Z
X1 A1 A2 int1 AND2_X1
X2 A1 A2 int2 NOR2_X1
X3 int1 int2 int3 NOR2_X1
X4 int3 Z INV_X1
.ENDS

.SUBCKT XNOR2_X1 A B Z
X1 A B Z_int XOR2_X1
X2 Z_int Z INV_X1
.ENDS

.SUBCKT BUF_X1 A Z
X1 A Z_bar INV_X1
X2 Z_bar Z INV_X1
.ENDS

.SUBCKT OAI21_X1 A B C Z
X1 A B C Z_bar AOI21_X1
X2 Z_bar Z INV_X1
.ENDS

.SUBCKT AOI21_X1 A B C Z
M1 Z A int1 1 PMOS W=0.4u L=0.05u
M2 int1 B 1 1 PMOS W=0.4u L=0.05u
M3 Z C 1 1 PMOS W=0.4u L=0.05u
M4 Z A 0 0 NMOS W=0.2u L=0.05u
M5 Z B 0 0 NMOS W=0.2u L=0.05u
M6 Z C 0 0 NMOS W=0.2u L=0.05u
.ENDS

.SUBCKT NAND3_X1 A1 A2 A3 Z
X1 A1 A2 int1 AND2_X1
X2 int1 A3 Z NAND2_X1
.ENDS

.SUBCKT AND3_X1 A1 A2 A3 Z
X1 A1 A2 A3 Z_bar NAND3_X1
X2 Z_bar Z INV_X1
.ENDS

.SUBCKT NOR3_X1 A1 A2 A3 Z
X1 A1 A2 int1 OR2_X1
X2 int1 A3 Z NOR2_X1
.ENDS

.SUBCKT OR3_X1 A1 A2 A3 Z
X1 A1 A2 A3 Z_bar NOR3_X1
X2 Z_bar Z INV_X1
.ENDS

.SUBCKT NAND4_X1 A1 A2 A3 A4 Z
X1 A1 A2 A3 int1 AND3_X1
X2 int1 A4 Z NAND2_X1
.ENDS

.SUBCKT AND4_X1 A1 A2 A3 A4 Z
X1 A1 A2 A3 A4 Z_bar NAND4_X1
X2 Z_bar Z INV_X1
.ENDS

.SUBCKT NOR4_X1 A1 A2 A3 A4 Z
X1 A1 A2 A3 int1 OR3_X1
X2 int1 A4 Z NOR2_X1
.ENDS

.SUBCKT OR4_X1 A1 A2 A3 A4 Z
X1 A1 A2 A3 A4 Z_bar NOR4_X1
X2 Z_bar Z INV_X1
.ENDS

.SUBCKT AOI22_X1 A B C D Z
X1 A B int1 AND2_X1
X2 C D int2 AND2_X1
X3 int1 int2 Z NOR2_X1
.ENDS

.SUBCKT OAI22_X1 A B C D Z
X1 A B int1 OR2_X1
X2 C D int2 OR2_X1
X3 int1 int2 Z NAND2_X1
.ENDS

.SUBCKT AOI211_X1 A B C D Z
X1 A B int1 AND2_X1
X2 int1 C D Z NOR3_X1
.ENDS

.SUBCKT OAI211_X1 A B C D Z
X1 A B int1 OR2_X1
X2 int1 C D Z NAND3_X1
.ENDS

.SUBCKT OAI33_X1 A B C D E F Z
X1 A B C int1 OR3_X1
X2 D E F int2 OR3_X1
X3 int1 int2 Z NAND2_X1
.ENDS

.SUBCKT AOI33_X1 A B C D E F Z
X1 A B C int1 AND3_X1
X2 D E F int2 AND3_X1
X3 int1 int2 Z NOR2_X1
.ENDS

.SUBCKT MUX2_X1 A B S Z
X1 S S_bar INV_X1
X2 A S_bar int1 AND2_X1
X3 B S int2 AND2_X1
X4 int1 int2 Z OR2_X1
.ENDS

.SUBCKT DFF_X1 D C Q QN
X1 D Q_int INV_X1
X2 Q_int Q INV_X1
X3 Q_int QN INV_X1
.ENDS

.SUBCKT DFFR_X1 D C RN Q QN
X1 D Q_int INV_X1
X2 Q_int Q INV_X1
X3 Q_int QN INV_X1
.ENDS

.SUBCKT DFFS_X1 C D Q QN SN
X1 D Q_int INV_X1
X2 Q_int Q INV_X1
X3 Q_int QN INV_X1
.ENDS

.SUBCKT DFFRS_X1 C D Q QN RN SN
X1 D Q_int INV_X1
X2 Q_int Q INV_X1
X3 Q_int QN INV_X1
.ENDS

* Provide VDD power source explicitly
Vvdd 1 0 1.8

* Auto-extracted Inputs:
V_CK CK 0 1.8
V_D D 0 0.0
V_CK CK 0 1.8
V_G0 G0 0 0.0
V_G1 G1 0 1.8
V_G2 G2 0 0.0
V_G3 G3 0 1.8

* Yosys Generated Netlist:
* SPICE netlist generated by Yosys 0.62 (git sha1 7326bb7d6641500ecb285c291a54a662cb1e76cf, clang++ 17.0.0 -fPIC -O3)

.SUBCKT dff CK Q D
X0 CK D Q 1 DFF_X1
.ENDS dff

X0 G5 1 INV_X1
X1 G0 2 INV_X1
X2 G1 G7 3 NOR2_X1
X3 G3 3 4 AND2_X1
X4 G6 2 3 G3 5 AOI22_X1
X5 G5 5 G11 NOR2_X1
X6 G5 5 G17 OR2_X1
X7 G2 3 G13 NOR2_X1
X8 2 4 1 G10 AOI21_X1
X9 CK G5 G10 dff
X10 CK G6 G11 dff
X11 CK G7 G13 dff

************************
* end of SPICE netlist *
************************

* Anti-Floating Pull-Downs (GMIN)
R_PD_0 G11 0 100meg
R_PD_1 G13 0 100meg
R_PD_2 1 0 100meg
R_PD_3 2 0 100meg
R_PD_4 G0 0 100meg
R_PD_5 G6 0 100meg
R_PD_6 G2 0 100meg
R_PD_7 G1 0 100meg
R_PD_8 G5 0 100meg
R_PD_9 CK 0 100meg
R_PD_10 Q 0 100meg
R_PD_11 G7 0 100meg
R_PD_12 G10 0 100meg
R_PD_13 D 0 100meg
R_PD_14 G3 0 100meg
R_PD_15 4 0 100meg
R_PD_16 3 0 100meg
R_PD_17 G17 0 100meg
R_PD_18 5 0 100meg

* Transient Simulation Directive
.TRAN 100p 10n
