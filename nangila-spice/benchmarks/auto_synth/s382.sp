* Nangila SPICE Auto-Synthesized Netlist
.SUBCKT INV_X1 A Z
M1 Z A 0 0 NMOS W=0.2u L=0.05u
M2 Z A 1 1 PMOS W=0.4u L=0.05u
.ENDS

.SUBCKT NAND2_X1 A1 A2 Z
M1 Z A1 1 1 PMOS W=0.4u L=0.05u
M2 Z A2 1 1 PMOS W=0.4u L=0.05u
M3 Z A1 int 0 NMOS W=0.2u L=0.05u
M4 int A2 0 0 NMOS W=0.2u L=0.05u
.ENDS

.SUBCKT AND2_X1 A1 A2 Z
X1 A1 A2 Z_bar NAND2_X1
X2 Z_bar Z INV_X1
.ENDS

.SUBCKT NOR2_X1 A1 A2 Z
M1 int1 A1 1 1 PMOS W=0.4u L=0.05u
M2 Z A2 int1 1 PMOS W=0.4u L=0.05u
M3 Z A1 0 0 NMOS W=0.2u L=0.05u
M4 Z A2 0 0 NMOS W=0.2u L=0.05u
.ENDS

.SUBCKT OR2_X1 A1 A2 Z
X1 A1 A2 Z_bar NOR2_X1
X2 Z_bar Z INV_X1
.ENDS

.SUBCKT XOR2_X1 A1 A2 Z
X1 A1 A2 int1 AND2_X1
X2 A1 A2 int2 NOR2_X1
X3 int1 int2 int3 NOR2_X1
X4 int3 Z INV_X1
.ENDS

.SUBCKT XNOR2_X1 A B Z
X1 A B Z_int XOR2_X1
X2 Z_int Z INV_X1
.ENDS

.SUBCKT BUF_X1 A Z
X1 A Z_bar INV_X1
X2 Z_bar Z INV_X1
.ENDS

.SUBCKT OAI21_X1 A B C Z
X1 A B C Z_bar AOI21_X1
X2 Z_bar Z INV_X1
.ENDS

.SUBCKT AOI21_X1 A B C Z
M1 Z A int1 1 PMOS W=0.4u L=0.05u
M2 int1 B 1 1 PMOS W=0.4u L=0.05u
M3 Z C 1 1 PMOS W=0.4u L=0.05u
M4 Z A 0 0 NMOS W=0.2u L=0.05u
M5 Z B 0 0 NMOS W=0.2u L=0.05u
M6 Z C 0 0 NMOS W=0.2u L=0.05u
.ENDS

.SUBCKT NAND3_X1 A1 A2 A3 Z
X1 A1 A2 int1 AND2_X1
X2 int1 A3 Z NAND2_X1
.ENDS

.SUBCKT AND3_X1 A1 A2 A3 Z
X1 A1 A2 A3 Z_bar NAND3_X1
X2 Z_bar Z INV_X1
.ENDS

.SUBCKT NOR3_X1 A1 A2 A3 Z
X1 A1 A2 int1 OR2_X1
X2 int1 A3 Z NOR2_X1
.ENDS

.SUBCKT OR3_X1 A1 A2 A3 Z
X1 A1 A2 A3 Z_bar NOR3_X1
X2 Z_bar Z INV_X1
.ENDS

.SUBCKT NAND4_X1 A1 A2 A3 A4 Z
X1 A1 A2 A3 int1 AND3_X1
X2 int1 A4 Z NAND2_X1
.ENDS

.SUBCKT AND4_X1 A1 A2 A3 A4 Z
X1 A1 A2 A3 A4 Z_bar NAND4_X1
X2 Z_bar Z INV_X1
.ENDS

.SUBCKT NOR4_X1 A1 A2 A3 A4 Z
X1 A1 A2 A3 int1 OR3_X1
X2 int1 A4 Z NOR2_X1
.ENDS

.SUBCKT OR4_X1 A1 A2 A3 A4 Z
X1 A1 A2 A3 A4 Z_bar NOR4_X1
X2 Z_bar Z INV_X1
.ENDS

.SUBCKT AOI22_X1 A B C D Z
X1 A B int1 AND2_X1
X2 C D int2 AND2_X1
X3 int1 int2 Z NOR2_X1
.ENDS

.SUBCKT OAI22_X1 A B C D Z
X1 A B int1 OR2_X1
X2 C D int2 OR2_X1
X3 int1 int2 Z NAND2_X1
.ENDS

.SUBCKT AOI211_X1 A B C D Z
X1 A B int1 AND2_X1
X2 int1 C D Z NOR3_X1
.ENDS

.SUBCKT OAI211_X1 A B C D Z
X1 A B int1 OR2_X1
X2 int1 C D Z NAND3_X1
.ENDS

.SUBCKT OAI33_X1 A B C D E F Z
X1 A B C int1 OR3_X1
X2 D E F int2 OR3_X1
X3 int1 int2 Z NAND2_X1
.ENDS

.SUBCKT AOI33_X1 A B C D E F Z
X1 A B C int1 AND3_X1
X2 D E F int2 AND3_X1
X3 int1 int2 Z NOR2_X1
.ENDS

.SUBCKT MUX2_X1 A B S Z
X1 S S_bar INV_X1
X2 A S_bar int1 AND2_X1
X3 B S int2 AND2_X1
X4 int1 int2 Z OR2_X1
.ENDS

.SUBCKT DFF_X1 D C Q QN
X1 D Q_int INV_X1
X2 Q_int Q INV_X1
X3 Q_int QN INV_X1
.ENDS

.SUBCKT DFFR_X1 D C RN Q QN
X1 D Q_int INV_X1
X2 Q_int Q INV_X1
X3 Q_int QN INV_X1
.ENDS

.SUBCKT DFFS_X1 C D Q QN SN
X1 D Q_int INV_X1
X2 Q_int Q INV_X1
X3 Q_int QN INV_X1
.ENDS

.SUBCKT DFFRS_X1 C D Q QN RN SN
X1 D Q_int INV_X1
X2 Q_int Q INV_X1
X3 Q_int QN INV_X1
.ENDS

* Provide VDD power source explicitly
Vvdd 1 0 1.8

* Auto-extracted Inputs:
V_CK CK 0 1.8
V_D D 0 0.0
V_CK CK 0 1.8
V_FM FM 0 0.0
V_TEST TEST 0 1.8
V_CLR CLR 0 0.0

* Yosys Generated Netlist:
* SPICE netlist generated by Yosys 0.62 (git sha1 7326bb7d6641500ecb285c291a54a662cb1e76cf, clang++ 17.0.0 -fPIC -O3)

.SUBCKT dff CK Q D
X0 CK D Q 1 DFF_X1
.ENDS dff

X0 C3_Q1 1 INV_X1
X1 FML 2 INV_X1
X2 CLR 3 INV_X1
X3 UC_8 4 INV_X1
X4 UC_16 5 INV_X1
X5 UC_19 6 INV_X1
X6 OLATCHVUC_5 RED2 INV_X1
X7 OLATCHVUC_6 YLW1 INV_X1
X8 C3_Q0 1 7 NAND2_X1
X9 C3_Q3 FML 8 NOR2_X1
X10 C3_Q3 FML 7 9 NOR3_X1
X11 C3_Q0 1 C3_Q2 8 10 AND4_X1
X12 OLATCH_FEL 3 11 NAND2_X1
X13 10 11 12 NOR2_X1
X14 C3_Q2 3 13 NAND2_X1
X15 C3_Q0 C3_Q1 14 NOR2_X1
X16 C3_Q0 C3_Q1 15 OR2_X1
X17 FML 14 16 NAND2_X1
X18 10 11 13 16 TCOMB_FE OAI22_X1
X19 3 FML FM 17 OAI21_X1
X20 17 FML FM FMLVIINLATCHVCDAD AOI21_X1
X21 3 TEST TESTL 18 OAI21_X1
X22 18 TESTL TEST TESTLVIINLATCHVCDAD AOI21_X1
X23 C3_Q3 3 19 NAND2_X1
X24 19 20 INV_X1
X25 11 13 21 NAND2_X1
X26 21 20 7 TCOMB_RA1 AOI21_X1
X27 UC_9 C1VCO0 UC_10 22 OR3_X1
X28 UC_8 22 23 NAND2_X1
X29 3 23 24 NAND2_X1
X30 C1VCO0 24 UC_11VD NOR2_X1
X31 C3_Q0 C3_Q1 25 NAND2_X1
X32 C3_Q0 19 25 CLR 26 OAI22_X1
X33 21 26 TCOMB_GA2 NOR2_X1
X34 OLATCH_FEL C3_Q2 CLR 25 TCOMB_YA2 NOR4_X1
X35 OLATCH_FEL C3_Q3 FML 27 AOI21_X1
X36 9 27 28 NOR2_X1
X37 13 28 14 FML TCOMB_GA1 AOI211_X1
X38 UC_9 C1VCO0 UC_10 29 NAND3_X1
X39 24 29 4 UC_8VD AOI21_X1
X40 UC_9 C1VCO0 UC_10 30 AOI21_X1
X41 24 30 31 NOR2_X1
X42 29 31 UC_9VD AND2_X1
X43 C1VCO0 UC_10 32 XNOR2_X1
X44 24 32 UC_10VD NOR2_X1
X45 TESTL UC_8 22 33 AOI21_X1
X46 6 33 34 NOR2_X1
X47 UC_17 UC_18 34 35 AND3_X1
X48 UC_17 UC_18 34 36 NAND3_X1
X49 UC_17 UC_18 UC_19 37 NOR3_X1
X50 5 37 38 OR2_X1
X51 33 38 39 NOR2_X1
X52 3 33 38 40 OAI21_X1
X53 40 36 5 UC_16VD AOI21_X1
X54 UC_17 UC_18 34 41 AOI21_X1
X55 35 40 41 UC_17VD NOR3_X1
X56 UC_18 34 42 XNOR2_X1
X57 40 42 UC_18VD NOR2_X1
X58 34 40 43 OR2_X1
X59 43 33 6 UC_19VD AOI21_X1
X60 UC_17 TCOMB_FE 44 NAND2_X1
X61 C3_Q3 C3_Q2 15 45 OAI21_X1
X62 3 45 C3_Q3 C3_Q2 46 OAI211_X1
X63 15 46 C3_Q2 2 47 AOI211_X1
X64 44 47 12 Y1C OAI21_X1
X65 13 15 19 48 OAI21_X1
X66 44 48 12 R2C OAI21_X1
X67 25 33 38 49 NOR3_X1
X68 C3_Q3 C3_Q2 49 50 AOI21_X1
X69 3 45 51 NAND2_X1
X70 40 51 52 AND2_X1
X71 50 52 C3_Q3VD NOR2_X1
X72 C3_Q2 49 53 XNOR2_X1
X73 52 53 C3_Q2VD NOR2_X1
X74 C3_Q1 39 C3_Q0 54 AOI21_X1
X75 49 52 54 C3_Q1VD NOR3_X1
X76 C3_Q0 39 55 XNOR2_X1
X77 52 55 C3_Q0VD NOR2_X1
X78 CK TESTL TESTLVIINLATCHVCDAD dff
X79 CK FML FMLVIINLATCHVCDAD dff
X80 CK C3_Q2 C3_Q2VD dff
X81 CK C3_Q1 C3_Q1VD dff
X82 CK C3_Q0 C3_Q0VD dff
X83 CK UC_16 UC_16VD dff
X84 CK UC_17 UC_17VD dff
X85 CK UC_18 UC_18VD dff
X86 CK UC_19 UC_19VD dff
X87 CK UC_8 UC_8VD dff
X88 CK UC_9 UC_9VD dff
X89 CK UC_10 UC_10VD dff
X90 CK OLATCH_Y2L TCOMB_YA2 dff
X91 CK C1VCO0 UC_11VD dff
X92 CK OLATCHVUC_6 Y1C dff
X93 CK OLATCHVUC_5 R2C dff
X94 CK OLATCH_R1L TCOMB_RA1 dff
X95 CK OLATCH_G2L TCOMB_GA2 dff
X96 CK OLATCH_G1L TCOMB_GA1 dff
X97 CK OLATCH_FEL TCOMB_FE dff
X98 CK C3_Q3 C3_Q3VD dff
V0 RED2 OLATCH_R2L DC 0
V1 YLW1 OLATCH_Y1L DC 0
V2 OLATCHVUC_5 OUTBUFVBUFR2VIIR1 DC 0
V3 OLATCHVUC_6 OUTBUFVBUFY1VIIR1 DC 0
V4 OLATCH_R1L RED1 DC 0
V5 OLATCH_G2L GRN2 DC 0
V6 TCOMB_FE TCOMB_FE_BF DC 0
V7 TEST TESTB DC 0
V8 OLATCH_G1L GRN1 DC 0
V9 C1VCO0 UC_11 DC 0
V10 C1VCO0 UC_11VZ DC 0
V11 CLR CLRB DC 0
V12 FM FMB DC 0
V13 OLATCH_Y2L YLW2 DC 0

************************
* end of SPICE netlist *
************************

* Anti-Floating Pull-Downs (GMIN)
R_PD_0 UC_8 0 100meg
R_PD_1 UC_17VD 0 100meg
R_PD_2 CLR 0 100meg
R_PD_3 RED2 0 100meg
R_PD_4 38 0 100meg
R_PD_5 21 0 100meg
R_PD_6 UC_9VD 0 100meg
R_PD_7 50 0 100meg
R_PD_8 UC_17 0 100meg
R_PD_9 TESTL 0 100meg
R_PD_10 24 0 100meg
R_PD_11 55 0 100meg
R_PD_12 9 0 100meg
R_PD_13 C3_Q2VD 0 100meg
R_PD_14 39 0 100meg
R_PD_15 12 0 100meg
R_PD_16 18 0 100meg
R_PD_17 D 0 100meg
R_PD_18 23 0 100meg
R_PD_19 30 0 100meg
R_PD_20 OLATCH_R1L 0 100meg
R_PD_21 40 0 100meg
R_PD_22 51 0 100meg
R_PD_23 C3_Q2 0 100meg
R_PD_24 OLATCH_FEL 0 100meg
R_PD_25 29 0 100meg
R_PD_26 52 0 100meg
R_PD_27 43 0 100meg
R_PD_28 26 0 100meg
R_PD_29 UC_10 0 100meg
R_PD_30 6 0 100meg
R_PD_31 FMLVIINLATCHVCDAD 0 100meg
R_PD_32 TCOMB_RA1 0 100meg
R_PD_33 1 0 100meg
R_PD_34 FM 0 100meg
R_PD_35 2 0 100meg
R_PD_36 UC_19VD 0 100meg
R_PD_37 48 0 100meg
R_PD_38 TESTLVIINLATCHVCDAD 0 100meg
R_PD_39 10 0 100meg
R_PD_40 OLATCHVUC_5 0 100meg
R_PD_41 UC_19 0 100meg
R_PD_42 15 0 100meg
R_PD_43 46 0 100meg
R_PD_44 TCOMB_FE 0 100meg
R_PD_45 37 0 100meg
R_PD_46 4 0 100meg
R_PD_47 UC_16VD 0 100meg
R_PD_48 3 0 100meg
R_PD_49 20 0 100meg
R_PD_50 OLATCHVUC_6 0 100meg
R_PD_51 UC_8VD 0 100meg
R_PD_52 7 0 100meg
R_PD_53 8 0 100meg
R_PD_54 16 0 100meg
R_PD_55 C3_Q3 0 100meg
R_PD_56 OLATCH_Y2L 0 100meg
R_PD_57 UC_18VD 0 100meg
R_PD_58 54 0 100meg
R_PD_59 C3_Q1 0 100meg
R_PD_60 TCOMB_GA2 0 100meg
R_PD_61 35 0 100meg
R_PD_62 Y1C 0 100meg
R_PD_63 UC_11VD 0 100meg
R_PD_64 17 0 100meg
R_PD_65 28 0 100meg
R_PD_66 CK 0 100meg
R_PD_67 34 0 100meg
R_PD_68 36 0 100meg
R_PD_69 33 0 100meg
R_PD_70 OLATCH_G1L 0 100meg
R_PD_71 53 0 100meg
R_PD_72 47 0 100meg
R_PD_73 C3_Q0 0 100meg
R_PD_74 TCOMB_YA2 0 100meg
R_PD_75 TCOMB_GA1 0 100meg
R_PD_76 R2C 0 100meg
R_PD_77 42 0 100meg
R_PD_78 C3_Q1VD 0 100meg
R_PD_79 UC_16 0 100meg
R_PD_80 22 0 100meg
R_PD_81 C3_Q0VD 0 100meg
R_PD_82 25 0 100meg
R_PD_83 UC_10VD 0 100meg
R_PD_84 TEST 0 100meg
R_PD_85 44 0 100meg
R_PD_86 45 0 100meg
R_PD_87 C3_Q3VD 0 100meg
R_PD_88 32 0 100meg
R_PD_89 41 0 100meg
R_PD_90 14 0 100meg
R_PD_91 49 0 100meg
R_PD_92 OLATCH_G2L 0 100meg
R_PD_93 19 0 100meg
R_PD_94 31 0 100meg
R_PD_95 UC_18 0 100meg
R_PD_96 Q 0 100meg
R_PD_97 C1VCO0 0 100meg
R_PD_98 27 0 100meg
R_PD_99 UC_9 0 100meg
R_PD_100 YLW1 0 100meg
R_PD_101 FML 0 100meg
R_PD_102 13 0 100meg
R_PD_103 11 0 100meg
R_PD_104 5 0 100meg

* Transient Simulation Directive
.TRAN 100p 10n
