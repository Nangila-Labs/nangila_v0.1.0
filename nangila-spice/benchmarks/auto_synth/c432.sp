* Nangila SPICE Auto-Synthesized Netlist
.SUBCKT INV_X1 A Z
M1 Z A 0 0 NMOS W=0.2u L=0.05u
M2 Z A 1 1 PMOS W=0.4u L=0.05u
.ENDS

.SUBCKT NAND2_X1 A1 A2 Z
M1 Z A1 1 1 PMOS W=0.4u L=0.05u
M2 Z A2 1 1 PMOS W=0.4u L=0.05u
M3 Z A1 int 0 NMOS W=0.2u L=0.05u
M4 int A2 0 0 NMOS W=0.2u L=0.05u
.ENDS

.SUBCKT AND2_X1 A1 A2 Z
X1 A1 A2 Z_bar NAND2_X1
X2 Z_bar Z INV_X1
.ENDS

.SUBCKT NOR2_X1 A1 A2 Z
M1 int1 A1 1 1 PMOS W=0.4u L=0.05u
M2 Z A2 int1 1 PMOS W=0.4u L=0.05u
M3 Z A1 0 0 NMOS W=0.2u L=0.05u
M4 Z A2 0 0 NMOS W=0.2u L=0.05u
.ENDS

.SUBCKT OR2_X1 A1 A2 Z
X1 A1 A2 Z_bar NOR2_X1
X2 Z_bar Z INV_X1
.ENDS

.SUBCKT XOR2_X1 A1 A2 Z
X1 A1 A2 int1 AND2_X1
X2 A1 A2 int2 NOR2_X1
X3 int1 int2 int3 NOR2_X1
X4 int3 Z INV_X1
.ENDS

.SUBCKT XNOR2_X1 A B Z
X1 A B Z_int XOR2_X1
X2 Z_int Z INV_X1
.ENDS

.SUBCKT BUF_X1 A Z
X1 A Z_bar INV_X1
X2 Z_bar Z INV_X1
.ENDS

.SUBCKT OAI21_X1 A B C Z
X1 A B C Z_bar AOI21_X1
X2 Z_bar Z INV_X1
.ENDS

.SUBCKT AOI21_X1 A B C Z
M1 Z A int1 1 PMOS W=0.4u L=0.05u
M2 int1 B 1 1 PMOS W=0.4u L=0.05u
M3 Z C 1 1 PMOS W=0.4u L=0.05u
M4 Z A 0 0 NMOS W=0.2u L=0.05u
M5 Z B 0 0 NMOS W=0.2u L=0.05u
M6 Z C 0 0 NMOS W=0.2u L=0.05u
.ENDS

.SUBCKT NAND3_X1 A1 A2 A3 Z
X1 A1 A2 int1 AND2_X1
X2 int1 A3 Z NAND2_X1
.ENDS

.SUBCKT AND3_X1 A1 A2 A3 Z
X1 A1 A2 A3 Z_bar NAND3_X1
X2 Z_bar Z INV_X1
.ENDS

.SUBCKT NOR3_X1 A1 A2 A3 Z
X1 A1 A2 int1 OR2_X1
X2 int1 A3 Z NOR2_X1
.ENDS

.SUBCKT OR3_X1 A1 A2 A3 Z
X1 A1 A2 A3 Z_bar NOR3_X1
X2 Z_bar Z INV_X1
.ENDS

.SUBCKT NAND4_X1 A1 A2 A3 A4 Z
X1 A1 A2 A3 int1 AND3_X1
X2 int1 A4 Z NAND2_X1
.ENDS

.SUBCKT AND4_X1 A1 A2 A3 A4 Z
X1 A1 A2 A3 A4 Z_bar NAND4_X1
X2 Z_bar Z INV_X1
.ENDS

.SUBCKT NOR4_X1 A1 A2 A3 A4 Z
X1 A1 A2 A3 int1 OR3_X1
X2 int1 A4 Z NOR2_X1
.ENDS

.SUBCKT OR4_X1 A1 A2 A3 A4 Z
X1 A1 A2 A3 A4 Z_bar NOR4_X1
X2 Z_bar Z INV_X1
.ENDS

.SUBCKT AOI22_X1 A B C D Z
X1 A B int1 AND2_X1
X2 C D int2 AND2_X1
X3 int1 int2 Z NOR2_X1
.ENDS

.SUBCKT OAI22_X1 A B C D Z
X1 A B int1 OR2_X1
X2 C D int2 OR2_X1
X3 int1 int2 Z NAND2_X1
.ENDS

.SUBCKT AOI211_X1 A B C D Z
X1 A B int1 AND2_X1
X2 int1 C D Z NOR3_X1
.ENDS

.SUBCKT OAI211_X1 A B C D Z
X1 A B int1 OR2_X1
X2 int1 C D Z NAND3_X1
.ENDS

.SUBCKT OAI33_X1 A B C D E F Z
X1 A B C int1 OR3_X1
X2 D E F int2 OR3_X1
X3 int1 int2 Z NAND2_X1
.ENDS

.SUBCKT AOI33_X1 A B C D E F Z
X1 A B C int1 AND3_X1
X2 D E F int2 AND3_X1
X3 int1 int2 Z NOR2_X1
.ENDS

.SUBCKT MUX2_X1 A B S Z
X1 S S_bar INV_X1
X2 A S_bar int1 AND2_X1
X3 B S int2 AND2_X1
X4 int1 int2 Z OR2_X1
.ENDS

.SUBCKT DFF_X1 D C Q QN
X1 D Q_int INV_X1
X2 Q_int Q INV_X1
X3 Q_int QN INV_X1
.ENDS

.SUBCKT DFFR_X1 D C RN Q QN
X1 D Q_int INV_X1
X2 Q_int Q INV_X1
X3 Q_int QN INV_X1
.ENDS

.SUBCKT DFFS_X1 C D Q QN SN
X1 D Q_int INV_X1
X2 Q_int Q INV_X1
X3 Q_int QN INV_X1
.ENDS

.SUBCKT DFFRS_X1 C D Q QN RN SN
X1 D Q_int INV_X1
X2 Q_int Q INV_X1
X3 Q_int QN INV_X1
.ENDS

* Provide VDD power source explicitly
Vvdd 1 0 1.8

* Auto-extracted Inputs:
V_N1 N1 0 1.8
V_N4 N4 0 0.0
V_N8 N8 0 1.8
V_N11 N11 0 0.0
V_N14 N14 0 1.8
V_N17 N17 0 0.0
V_N21 N21 0 1.8
V_N24 N24 0 0.0
V_N27 N27 0 1.8
V_N30 N30 0 0.0
V_N34 N34 0 1.8
V_N37 N37 0 0.0
V_N40 N40 0 1.8
V_N43 N43 0 0.0
V_N47 N47 0 1.8
V_N50 N50 0 0.0
V_N53 N53 0 1.8
V_N56 N56 0 0.0
V_N60 N60 0 1.8
V_N63 N63 0 0.0
V_N66 N66 0 1.8
V_N69 N69 0 0.0
V_N73 N73 0 1.8
V_N76 N76 0 0.0
V_N79 N79 0 1.8
V_N82 N82 0 0.0
V_N86 N86 0 1.8
V_N89 N89 0 0.0
V_N92 N92 0 1.8
V_N95 N95 0 0.0
V_N99 N99 0 1.8
V_N102 N102 0 0.0
V_N105 N105 0 1.8
V_N108 N108 0 0.0
V_N112 N112 0 1.8
V_N115 N115 0 0.0

* Yosys Generated Netlist:
* SPICE netlist generated by Yosys 0.62 (git sha1 7326bb7d6641500ecb285c291a54a662cb1e76cf, clang++ 17.0.0 -fPIC -O3)

X0 N4 1 INV_X1
X1 N8 2 INV_X1
X2 N17 3 INV_X1
X3 N30 4 INV_X1
X4 N43 5 INV_X1
X5 N56 6 INV_X1
X6 N69 7 INV_X1
X7 N82 8 INV_X1
X8 N95 9 INV_X1
X9 N108 10 INV_X1
X10 N47 11 INV_X1
X11 1 N1 N11 3 12 OAI22_X1
X12 4 N24 N50 6 13 OAI22_X1
X13 8 N76 N89 9 N102 10 14 OAI222_X1
X14 5 N37 N63 7 15 OAI22_X1
X15 12 13 14 15 N223 OR4_X1
X16 N37 N223 16 NAND2_X1
X17 N43 16 17 NAND2_X1
X18 N43 11 16 18 NAND3_X1
X19 N24 N223 19 NAND2_X1
X20 N30 19 20 NAND2_X1
X21 4 N34 N24 N223 21 AOI211_X1
X22 N76 N223 22 NAND2_X1
X23 N82 22 23 NAND2_X1
X24 8 N86 N76 N223 24 AOI211_X1
X25 N63 N223 25 NAND2_X1
X26 N69 25 26 NAND2_X1
X27 7 N73 N63 N223 27 AOI211_X1
X28 N89 N223 28 NAND2_X1
X29 N95 28 29 NAND2_X1
X30 9 N99 N89 N223 30 AOI211_X1
X31 N1 N223 31 NAND2_X1
X32 N4 31 32 NAND2_X1
X33 N4 2 31 33 NAND3_X1
X34 N50 N223 34 NAND2_X1
X35 N56 34 35 NAND2_X1
X36 6 N60 N50 N223 36 AOI211_X1
X37 N11 N223 37 NAND2_X1
X38 N17 37 38 NAND2_X1
X39 3 N21 N11 N223 39 AOI211_X1
X40 N102 N223 40 NAND2_X1
X41 N108 40 41 NAND2_X1
X42 10 N112 N102 N223 42 AOI211_X1
X43 21 36 39 43 NOR3_X1
X44 24 27 30 42 44 NOR4_X1
X45 18 33 43 44 N329 NAND4_X1
X46 N27 38 N329 N21 45 AOI211_X1
X47 N40 20 N329 N34 46 AOI211_X1
X48 26 N329 N73 47 AOI21_X1
X49 N79 26 N329 N73 48 AOI211_X1
X50 N53 17 N329 N47 49 AOI211_X1
X51 23 N329 N86 50 AOI21_X1
X52 N92 23 N329 N86 51 AOI211_X1
X53 N14 32 N329 N8 52 AOI211_X1
X54 N66 35 N329 N60 53 AOI211_X1
X55 N105 29 N329 N99 54 AOI211_X1
X56 N115 41 N329 N112 55 AOI211_X1
X57 45 48 49 52 56 NOR4_X1
X58 46 53 54 57 NOR3_X1
X59 51 55 58 NOR2_X1
X60 56 57 58 59 AND3_X1
X61 59 N370 INV_X1
X62 17 N329 N47 N370 N53 60 AOI221_X1
X63 35 N329 N60 N370 N66 61 AOI221_X1
X64 20 N329 N34 N370 N40 62 AOI221_X1
X65 60 61 62 63 OR3_X1
X66 38 N329 N21 N370 N27 64 AOI221_X1
X67 64 65 INV_X1
X68 60 61 62 64 66 NOR4_X1
X69 66 N430 INV_X1
X70 26 N329 N73 N370 N79 67 AOI221_X1
X71 48 59 47 68 AOI21_X1
X72 41 N329 N112 N370 N115 69 AOI221_X1
X73 23 N329 N86 N370 N92 70 AOI221_X1
X74 51 59 50 71 AOI21_X1
X75 29 N329 N99 N370 N105 72 AOI221_X1
X76 67 69 70 72 73 NOR4_X1
X77 32 N329 N8 N370 N14 74 AOI221_X1
X78 74 73 66 N421 AOI21_X1
X79 60 61 71 75 OR3_X1
X80 62 64 76 NOR2_X1
X81 75 76 63 68 N431 OAI211_X1
X82 60 71 72 77 AOI21_X1
X83 65 68 63 77 62 N432 OAI221_X1
V0 N329 N309 DC 0
V1 N329 N319 DC 0
V2 N370 N360 DC 0
V3 N223 N203 DC 0
V4 N223 N213 DC 0

************************
* end of SPICE netlist *
************************

* Anti-Floating Pull-Downs (GMIN)
R_PD_0 N76 0 100meg
R_PD_1 N63 0 100meg
R_PD_2 38 0 100meg
R_PD_3 21 0 100meg
R_PD_4 69 0 100meg
R_PD_5 N14 0 100meg
R_PD_6 50 0 100meg
R_PD_7 N421 0 100meg
R_PD_8 N223 0 100meg
R_PD_9 N4 0 100meg
R_PD_10 60 0 100meg
R_PD_11 65 0 100meg
R_PD_12 N53 0 100meg
R_PD_13 72 0 100meg
R_PD_14 24 0 100meg
R_PD_15 N34 0 100meg
R_PD_16 55 0 100meg
R_PD_17 57 0 100meg
R_PD_18 9 0 100meg
R_PD_19 39 0 100meg
R_PD_20 N112 0 100meg
R_PD_21 12 0 100meg
R_PD_22 18 0 100meg
R_PD_23 76 0 100meg
R_PD_24 N115 0 100meg
R_PD_25 N92 0 100meg
R_PD_26 23 0 100meg
R_PD_27 30 0 100meg
R_PD_28 66 0 100meg
R_PD_29 40 0 100meg
R_PD_30 51 0 100meg
R_PD_31 29 0 100meg
R_PD_32 52 0 100meg
R_PD_33 43 0 100meg
R_PD_34 26 0 100meg
R_PD_35 6 0 100meg
R_PD_36 64 0 100meg
R_PD_37 1 0 100meg
R_PD_38 61 0 100meg
R_PD_39 2 0 100meg
R_PD_40 73 0 100meg
R_PD_41 N43 0 100meg
R_PD_42 48 0 100meg
R_PD_43 N69 0 100meg
R_PD_44 75 0 100meg
R_PD_45 58 0 100meg
R_PD_46 10 0 100meg
R_PD_47 N329 0 100meg
R_PD_48 N30 0 100meg
R_PD_49 56 0 100meg
R_PD_50 68 0 100meg
R_PD_51 74 0 100meg
R_PD_52 15 0 100meg
R_PD_53 46 0 100meg
R_PD_54 37 0 100meg
R_PD_55 4 0 100meg
R_PD_56 3 0 100meg
R_PD_57 N1 0 100meg
R_PD_58 20 0 100meg
R_PD_59 N24 0 100meg
R_PD_60 N370 0 100meg
R_PD_61 7 0 100meg
R_PD_62 8 0 100meg
R_PD_63 N56 0 100meg
R_PD_64 16 0 100meg
R_PD_65 70 0 100meg
R_PD_66 N60 0 100meg
R_PD_67 77 0 100meg
R_PD_68 54 0 100meg
R_PD_69 N82 0 100meg
R_PD_70 35 0 100meg
R_PD_71 N79 0 100meg
R_PD_72 17 0 100meg
R_PD_73 N99 0 100meg
R_PD_74 28 0 100meg
R_PD_75 N66 0 100meg
R_PD_76 34 0 100meg
R_PD_77 36 0 100meg
R_PD_78 N40 0 100meg
R_PD_79 N89 0 100meg
R_PD_80 33 0 100meg
R_PD_81 N37 0 100meg
R_PD_82 N430 0 100meg
R_PD_83 53 0 100meg
R_PD_84 59 0 100meg
R_PD_85 N102 0 100meg
R_PD_86 47 0 100meg
R_PD_87 N431 0 100meg
R_PD_88 63 0 100meg
R_PD_89 42 0 100meg
R_PD_90 N86 0 100meg
R_PD_91 N108 0 100meg
R_PD_92 N17 0 100meg
R_PD_93 22 0 100meg
R_PD_94 25 0 100meg
R_PD_95 N95 0 100meg
R_PD_96 44 0 100meg
R_PD_97 45 0 100meg
R_PD_98 71 0 100meg
R_PD_99 N73 0 100meg
R_PD_100 32 0 100meg
R_PD_101 N47 0 100meg
R_PD_102 41 0 100meg
R_PD_103 14 0 100meg
R_PD_104 N8 0 100meg
R_PD_105 49 0 100meg
R_PD_106 62 0 100meg
R_PD_107 19 0 100meg
R_PD_108 N27 0 100meg
R_PD_109 N50 0 100meg
R_PD_110 31 0 100meg
R_PD_111 N21 0 100meg
R_PD_112 27 0 100meg
R_PD_113 67 0 100meg
R_PD_114 N432 0 100meg
R_PD_115 N105 0 100meg
R_PD_116 13 0 100meg
R_PD_117 11 0 100meg
R_PD_118 N11 0 100meg
R_PD_119 5 0 100meg

* Transient Simulation Directive
.TRAN 100p 10n
