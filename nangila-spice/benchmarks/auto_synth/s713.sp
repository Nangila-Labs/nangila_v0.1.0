* Nangila SPICE Auto-Synthesized Netlist
.SUBCKT INV_X1 A Z
M1 Z A 0 0 NMOS W=0.2u L=0.05u
M2 Z A 1 1 PMOS W=0.4u L=0.05u
.ENDS

.SUBCKT NAND2_X1 A1 A2 Z
M1 Z A1 1 1 PMOS W=0.4u L=0.05u
M2 Z A2 1 1 PMOS W=0.4u L=0.05u
M3 Z A1 int 0 NMOS W=0.2u L=0.05u
M4 int A2 0 0 NMOS W=0.2u L=0.05u
.ENDS

.SUBCKT AND2_X1 A1 A2 Z
X1 A1 A2 Z_bar NAND2_X1
X2 Z_bar Z INV_X1
.ENDS

.SUBCKT NOR2_X1 A1 A2 Z
M1 int1 A1 1 1 PMOS W=0.4u L=0.05u
M2 Z A2 int1 1 PMOS W=0.4u L=0.05u
M3 Z A1 0 0 NMOS W=0.2u L=0.05u
M4 Z A2 0 0 NMOS W=0.2u L=0.05u
.ENDS

.SUBCKT OR2_X1 A1 A2 Z
X1 A1 A2 Z_bar NOR2_X1
X2 Z_bar Z INV_X1
.ENDS

.SUBCKT XOR2_X1 A1 A2 Z
X1 A1 A2 int1 AND2_X1
X2 A1 A2 int2 NOR2_X1
X3 int1 int2 int3 NOR2_X1
X4 int3 Z INV_X1
.ENDS

.SUBCKT XNOR2_X1 A B Z
X1 A B Z_int XOR2_X1
X2 Z_int Z INV_X1
.ENDS

.SUBCKT BUF_X1 A Z
X1 A Z_bar INV_X1
X2 Z_bar Z INV_X1
.ENDS

.SUBCKT OAI21_X1 A B C Z
X1 A B C Z_bar AOI21_X1
X2 Z_bar Z INV_X1
.ENDS

.SUBCKT AOI21_X1 A B C Z
M1 Z A int1 1 PMOS W=0.4u L=0.05u
M2 int1 B 1 1 PMOS W=0.4u L=0.05u
M3 Z C 1 1 PMOS W=0.4u L=0.05u
M4 Z A 0 0 NMOS W=0.2u L=0.05u
M5 Z B 0 0 NMOS W=0.2u L=0.05u
M6 Z C 0 0 NMOS W=0.2u L=0.05u
.ENDS

.SUBCKT NAND3_X1 A1 A2 A3 Z
X1 A1 A2 int1 AND2_X1
X2 int1 A3 Z NAND2_X1
.ENDS

.SUBCKT AND3_X1 A1 A2 A3 Z
X1 A1 A2 A3 Z_bar NAND3_X1
X2 Z_bar Z INV_X1
.ENDS

.SUBCKT NOR3_X1 A1 A2 A3 Z
X1 A1 A2 int1 OR2_X1
X2 int1 A3 Z NOR2_X1
.ENDS

.SUBCKT OR3_X1 A1 A2 A3 Z
X1 A1 A2 A3 Z_bar NOR3_X1
X2 Z_bar Z INV_X1
.ENDS

.SUBCKT NAND4_X1 A1 A2 A3 A4 Z
X1 A1 A2 A3 int1 AND3_X1
X2 int1 A4 Z NAND2_X1
.ENDS

.SUBCKT AND4_X1 A1 A2 A3 A4 Z
X1 A1 A2 A3 A4 Z_bar NAND4_X1
X2 Z_bar Z INV_X1
.ENDS

.SUBCKT NOR4_X1 A1 A2 A3 A4 Z
X1 A1 A2 A3 int1 OR3_X1
X2 int1 A4 Z NOR2_X1
.ENDS

.SUBCKT OR4_X1 A1 A2 A3 A4 Z
X1 A1 A2 A3 A4 Z_bar NOR4_X1
X2 Z_bar Z INV_X1
.ENDS

.SUBCKT AOI22_X1 A B C D Z
X1 A B int1 AND2_X1
X2 C D int2 AND2_X1
X3 int1 int2 Z NOR2_X1
.ENDS

.SUBCKT OAI22_X1 A B C D Z
X1 A B int1 OR2_X1
X2 C D int2 OR2_X1
X3 int1 int2 Z NAND2_X1
.ENDS

.SUBCKT AOI211_X1 A B C D Z
X1 A B int1 AND2_X1
X2 int1 C D Z NOR3_X1
.ENDS

.SUBCKT OAI211_X1 A B C D Z
X1 A B int1 OR2_X1
X2 int1 C D Z NAND3_X1
.ENDS

.SUBCKT OAI33_X1 A B C D E F Z
X1 A B C int1 OR3_X1
X2 D E F int2 OR3_X1
X3 int1 int2 Z NAND2_X1
.ENDS

.SUBCKT AOI33_X1 A B C D E F Z
X1 A B C int1 AND3_X1
X2 D E F int2 AND3_X1
X3 int1 int2 Z NOR2_X1
.ENDS

.SUBCKT MUX2_X1 A B S Z
X1 S S_bar INV_X1
X2 A S_bar int1 AND2_X1
X3 B S int2 AND2_X1
X4 int1 int2 Z OR2_X1
.ENDS

.SUBCKT DFF_X1 D C Q QN
X1 D Q_int INV_X1
X2 Q_int Q INV_X1
X3 Q_int QN INV_X1
.ENDS

.SUBCKT DFFR_X1 D C RN Q QN
X1 D Q_int INV_X1
X2 Q_int Q INV_X1
X3 Q_int QN INV_X1
.ENDS

.SUBCKT DFFS_X1 C D Q QN SN
X1 D Q_int INV_X1
X2 Q_int Q INV_X1
X3 Q_int QN INV_X1
.ENDS

.SUBCKT DFFRS_X1 C D Q QN RN SN
X1 D Q_int INV_X1
X2 Q_int Q INV_X1
X3 Q_int QN INV_X1
.ENDS

* Provide VDD power source explicitly
Vvdd 1 0 1.8

* Auto-extracted Inputs:
V_CK CK 0 1.8
V_D D 0 0.0
V_CK CK 0 1.8
V_G1 G1 0 0.0
V_G2 G2 0 1.8
V_G3 G3 0 0.0
V_G4 G4 0 1.8
V_G5 G5 0 0.0
V_G6 G6 0 1.8
V_G8 G8 0 0.0
V_G9 G9 0 1.8
V_G10 G10 0 0.0
V_G11 G11 0 1.8
V_G12 G12 0 0.0
V_G13 G13 0 1.8
V_G14 G14 0 0.0
V_G15 G15 0 1.8
V_G16 G16 0 0.0
V_G17 G17 0 1.8
V_G18 G18 0 0.0
V_G19 G19 0 1.8
V_G20 G20 0 0.0
V_G21 G21 0 1.8
V_G22 G22 0 0.0
V_G23 G23 0 1.8
V_G24 G24 0 0.0
V_G25 G25 0 1.8
V_G26 G26 0 0.0
V_G27 G27 0 1.8
V_G28 G28 0 0.0
V_G29 G29 0 1.8
V_G30 G30 0 0.0
V_G31 G31 0 1.8
V_G32 G32 0 0.0
V_G33 G33 0 1.8
V_G34 G34 0 0.0
V_G35 G35 0 1.8
V_G36 G36 0 0.0

* Yosys Generated Netlist:
* SPICE netlist generated by Yosys 0.62 (git sha1 7326bb7d6641500ecb285c291a54a662cb1e76cf, clang++ 17.0.0 -fPIC -O3)

.SUBCKT dff CK Q D
X0 CK D Q 1 DFF_X1
.ENDS dff

X0 G13 1 INV_X1
X1 G111 2 INV_X1
X2 G115 3 INV_X1
X3 G119 4 INV_X1
X4 G23 5 INV_X1
X5 G25 6 INV_X1
X6 G215 7 INV_X1
X7 G211 8 INV_X1
X8 G24 9 INV_X1
X9 G213 10 INV_X1
X10 G22 11 INV_X1
X11 G121 12 INV_X1
X12 G209 13 INV_X1
X13 G2 14 INV_X1
X14 G3 15 INV_X1
X15 G217 G18 16 NAND2_X1
X16 G4 16 G107 NOR2_X1
X17 G219 G19 17 NAND2_X1
X18 G4 17 G83 NOR2_X1
X19 G221 G20 18 NAND2_X1
X20 G4 18 G84 NOR2_X1
X21 G223 G21 19 NAND2_X1
X22 G4 19 G85 NOR2_X1
X23 G11 G12 G13 G28 G92 AND4_X1
X24 1 G10 20 NAND2_X1
X25 1 G10 G9 15 21 NAND4_X1
X26 G11 G3 22 NOR2_X1
X27 6 G67 22 23 NOR3_X1
X28 21 23 24 AND2_X1
X29 24 G89BF INV_X1
X30 G3 21 23 25 AOI21_X1
X31 7 25 26 NOR2_X1
X32 7 25 27 OR2_X1
X33 G2 27 G132 NOR2_X1
X34 G9 G3 28 NOR2_X1
X35 G9 G3 20 29 NOR3_X1
X36 5 G65 22 29 30 NOR4_X1
X37 30 G87BF INV_X1
X38 G66 14 25 7 31 OAI211_X1
X39 G13 G10 32 NOR2_X1
X40 G9 32 33 NAND2_X1
X41 G3 33 G11 34 AOI21_X1
X42 9 34 35 NOR2_X1
X43 31 35 36 AND2_X1
X44 36 G88BF INV_X1
X45 G3 31 35 37 AOI21_X1
X46 10 37 38 OR2_X1
X47 38 G158 INV_X1
X48 G2 26 38 G131 NOR3_X1
X49 8 15 G87BF 39 AOI21_X1
X50 G211 G3 30 40 OAI21_X1
X51 27 38 41 NAND2_X1
X52 G2 40 41 G130 NOR3_X1
X53 39 41 42 NOR2_X1
X54 27 40 37 10 43 OAI211_X1
X55 G64 14 44 NAND2_X1
X56 11 22 28 32 45 AOI211_X1
X57 45 44 43 G86BF OAI21_X1
X58 13 15 G86BF G150 AOI21_X1
X59 G150 46 INV_X1
X60 G2 43 46 G129 NOR3_X1
X61 12 G86BF 47 NOR2_X1
X62 4 G4 48 NOR2_X1
X63 G113 36 49 AND2_X1
X64 2 G4 50 NOR2_X1
X65 49 50 51 NAND2_X1
X66 3 G4 52 NOR2_X1
X67 G117 30 53 NAND2_X1
X68 3 G4 53 54 NOR3_X1
X69 G109 24 G122 AND2_X1
X70 G122 55 INV_X1
X71 54 G122 56 NAND2_X1
X72 G13 G10 G9 51 56 G11 57 OAI33_X1
X73 47 48 57 58 AND3_X1
X74 33 51 59 NOR2_X1
X75 20 55 G9 60 AOI21_X1
X76 60 54 G9 61 OAI21_X1
X77 G12 G26 61 62 NAND3_X1
X78 58 59 62 G90 NOR3_X1
X79 42 47 48 63 NAND3_X1
X80 G8 14 G150 64 AOI21_X1
X81 64 63 46 G125 AOI21_X1
X82 G5 27 38 54 65 NAND4_X1
X83 39 14 G5 66 OAI21_X1
X84 66 65 G150 G126 OAI21_X1
X85 39 G150 67 OR2_X1
X86 G6 27 49 50 68 NAND4_X1
X87 G158 14 G6 69 OAI21_X1
X88 69 68 67 G127 OAI21_X1
X89 G1 38 G122 70 NAND3_X1
X90 26 14 G1 71 OAI21_X1
X91 71 70 67 G128 OAI21_X1
X92 50 G113 36 G133 MUX2_X1
X93 G35 50 G100BF NAND2_X1
X94 G33 52 G98BF NAND2_X1
X95 G31 48 G96BF NAND2_X1
X96 G36 G122 G101BF NAND2_X1
X97 G17 26 G106BF NAND2_X1
X98 G117 G32 30 G97BF NAND3_X1
X99 G15 39 G104BF NAND2_X1
X100 52 53 G140 NAND2_X1
X101 G87BF 52 72 NAND2_X1
X102 53 72 G139 NAND2_X1
X103 G34 49 G99BF NAND2_X1
X104 G16 G158 G105BF NAND2_X1
X105 2 G4 49 G138 OR3_X1
X106 G30 47 G95BF NAND2_X1
X107 G14 G150 G103BF NAND2_X1
X108 48 G86BF 12 G142 OAI21_X1
X109 G121 48 G86BF G141 MUX2_X1
X110 CK G64 G150 dff
X111 CK G65 G130 dff
X112 CK G121 G142 dff
X113 CK G209 G125 dff
X114 CK G211 G126 dff
X115 CK G213 G127 dff
X116 CK G215 G128 dff
X117 CK G217 G129 dff
X118 CK G219 G130 dff
X119 CK G221 G131 dff
X120 CK G223 G132 dff
X121 CK G66 G158 dff
X122 CK G67 G132 dff
X123 CK G109 G122 dff
X124 CK G111 G133 dff
X125 CK G113 G138 dff
X126 CK G115 G139 dff
X127 CK G117 G140 dff
X128 CK G119 G141 dff
V0 G128 G274 DC 0
V1 G127 G273 DC 0
V2 G126 G272 DC 0
V3 G150 G300 DC 0
V4 G150 G301 DC 0
V5 G125 G271 DC 0
V6 G158 G306 DC 0
V7 G158 G307 DC 0
V8 G130 G262 DC 0
V9 G132 G250 DC 0
V10 G1 G352 DC 0
V11 G86BF G354 DC 0
V12 G87BF G356 DC 0
V13 G88BF G358 DC 0
V14 G89BF G359 DC 0
V15 G4 G360 DC 0
V16 G5 G361 DC 0
V17 G6 G362 DC 0
V18 G8 G363 DC 0
V19 G9 G364 DC 0
V20 G10 G367 DC 0
V21 G150 G380 DC 0
V22 G11 G386 DC 0
V23 G12 G388 DC 0
V24 G13 G389 DC 0
V25 G158 G394 DC 0
V26 G109 G68 DC 0
V27 G111 G69 DC 0
V28 G113 G70 DC 0
V29 G115 G71 DC 0
V30 G117 G72 DC 0
V31 G119 G73 DC 0
V32 G121 G74 DC 0
V33 G209 G75 DC 0
V34 G211 G76 DC 0
V35 G213 G77 DC 0
V36 G215 G78 DC 0
V37 G217 G79 DC 0
V38 G219 G80 DC 0
V39 G221 G81 DC 0
V40 G223 G82 DC 0
V41 G130 G276 DC 0
V42 G131 G277 DC 0
V43 G132 G278 DC 0
V44 G27 G91 DC 0
V45 G29 G94 DC 0
V46 G132 G229 DC 0
V47 G87BF II335 DC 0
V48 G89BF II338 DC 0
V49 G87BF II341 DC 0
V50 G88BF II449 DC 0
V51 G88BF II452 DC 0
V52 G86BF II524 DC 0
V53 G86BF II527 DC 0
V54 G122 IIII208 DC 0
V55 Vdd IIII209 DC 0
V56 Vdd IIII223 DC 0
V57 G133 IIII285 DC 0
V58 Vdd IIII286 DC 0
V59 Vdd IIII293 DC 0
V60 G129 G275 DC 0
V61 Vdd IIII300 DC 0
V62 Vdd IIII307 DC 0
V63 Vdd IIII314 DC 0
V64 G138 IIII320 DC 0
V65 Vdd IIII321 DC 0
V66 G139 IIII327 DC 0
V67 Vdd IIII328 DC 0
V68 G140 IIII334 DC 0
V69 Vdd IIII335 DC 0
V70 G141 IIII341 DC 0
V71 Vdd IIII342 DC 0
V72 G142 IIII348 DC 0
V73 Vdd IIII349 DC 0
V74 G86BF IIII398 DC 0
V75 G87BF IIII406 DC 0
V76 G88BF IIII414 DC 0
V77 G89BF IIII422 DC 0

************************
* end of SPICE netlist *
************************

* Anti-Floating Pull-Downs (GMIN)
R_PD_0 G67 0 100meg
R_PD_1 G104BF 0 100meg
R_PD_2 G92 0 100meg
R_PD_3 G31 0 100meg
R_PD_4 G117 0 100meg
R_PD_5 38 0 100meg
R_PD_6 G223 0 100meg
R_PD_7 G115 0 100meg
R_PD_8 21 0 100meg
R_PD_9 69 0 100meg
R_PD_10 50 0 100meg
R_PD_11 G32 0 100meg
R_PD_12 G140 0 100meg
R_PD_13 G88BF 0 100meg
R_PD_14 60 0 100meg
R_PD_15 65 0 100meg
R_PD_16 72 0 100meg
R_PD_17 24 0 100meg
R_PD_18 G25 0 100meg
R_PD_19 55 0 100meg
R_PD_20 57 0 100meg
R_PD_21 G96BF 0 100meg
R_PD_22 9 0 100meg
R_PD_23 G30 0 100meg
R_PD_24 G95BF 0 100meg
R_PD_25 39 0 100meg
R_PD_26 12 0 100meg
R_PD_27 G20 0 100meg
R_PD_28 18 0 100meg
R_PD_29 G15 0 100meg
R_PD_30 G90 0 100meg
R_PD_31 D 0 100meg
R_PD_32 G97BF 0 100meg
R_PD_33 G3 0 100meg
R_PD_34 23 0 100meg
R_PD_35 30 0 100meg
R_PD_36 66 0 100meg
R_PD_37 40 0 100meg
R_PD_38 G126 0 100meg
R_PD_39 G17 0 100meg
R_PD_40 G121 0 100meg
R_PD_41 51 0 100meg
R_PD_42 29 0 100meg
R_PD_43 52 0 100meg
R_PD_44 43 0 100meg
R_PD_45 26 0 100meg
R_PD_46 G8 0 100meg
R_PD_47 6 0 100meg
R_PD_48 G83 0 100meg
R_PD_49 G11 0 100meg
R_PD_50 G109 0 100meg
R_PD_51 G107 0 100meg
R_PD_52 1 0 100meg
R_PD_53 64 0 100meg
R_PD_54 G28 0 100meg
R_PD_55 G87BF 0 100meg
R_PD_56 61 0 100meg
R_PD_57 2 0 100meg
R_PD_58 48 0 100meg
R_PD_59 G213 0 100meg
R_PD_60 G84 0 100meg
R_PD_61 G66 0 100meg
R_PD_62 58 0 100meg
R_PD_63 G4 0 100meg
R_PD_64 10 0 100meg
R_PD_65 G132 0 100meg
R_PD_66 G129 0 100meg
R_PD_67 G36 0 100meg
R_PD_68 G86BF 0 100meg
R_PD_69 G150 0 100meg
R_PD_70 G33 0 100meg
R_PD_71 56 0 100meg
R_PD_72 G99BF 0 100meg
R_PD_73 68 0 100meg
R_PD_74 15 0 100meg
R_PD_75 46 0 100meg
R_PD_76 37 0 100meg
R_PD_77 4 0 100meg
R_PD_78 3 0 100meg
R_PD_79 20 0 100meg
R_PD_80 G19 0 100meg
R_PD_81 G85 0 100meg
R_PD_82 G133 0 100meg
R_PD_83 7 0 100meg
R_PD_84 8 0 100meg
R_PD_85 16 0 100meg
R_PD_86 G9 0 100meg
R_PD_87 70 0 100meg
R_PD_88 G131 0 100meg
R_PD_89 G128 0 100meg
R_PD_90 G13 0 100meg
R_PD_91 G105BF 0 100meg
R_PD_92 G221 0 100meg
R_PD_93 G219 0 100meg
R_PD_94 G18 0 100meg
R_PD_95 G100BF 0 100meg
R_PD_96 G215 0 100meg
R_PD_97 54 0 100meg
R_PD_98 35 0 100meg
R_PD_99 G119 0 100meg
R_PD_100 G89BF 0 100meg
R_PD_101 G6 0 100meg
R_PD_102 G2 0 100meg
R_PD_103 G21 0 100meg
R_PD_104 17 0 100meg
R_PD_105 G14 0 100meg
R_PD_106 28 0 100meg
R_PD_107 G1 0 100meg
R_PD_108 CK 0 100meg
R_PD_109 34 0 100meg
R_PD_110 36 0 100meg
R_PD_111 G122 0 100meg
R_PD_112 G34 0 100meg
R_PD_113 G101BF 0 100meg
R_PD_114 33 0 100meg
R_PD_115 G141 0 100meg
R_PD_116 G139 0 100meg
R_PD_117 G158 0 100meg
R_PD_118 G10 0 100meg
R_PD_119 53 0 100meg
R_PD_120 59 0 100meg
R_PD_121 G125 0 100meg
R_PD_122 G103BF 0 100meg
R_PD_123 G130 0 100meg
R_PD_124 47 0 100meg
R_PD_125 63 0 100meg
R_PD_126 42 0 100meg
R_PD_127 G64 0 100meg
R_PD_128 G98BF 0 100meg
R_PD_129 G12 0 100meg
R_PD_130 G209 0 100meg
R_PD_131 G23 0 100meg
R_PD_132 22 0 100meg
R_PD_133 25 0 100meg
R_PD_134 44 0 100meg
R_PD_135 45 0 100meg
R_PD_136 71 0 100meg
R_PD_137 G65 0 100meg
R_PD_138 32 0 100meg
R_PD_139 41 0 100meg
R_PD_140 G26 0 100meg
R_PD_141 14 0 100meg
R_PD_142 49 0 100meg
R_PD_143 62 0 100meg
R_PD_144 19 0 100meg
R_PD_145 G5 0 100meg
R_PD_146 G217 0 100meg
R_PD_147 G106BF 0 100meg
R_PD_148 G16 0 100meg
R_PD_149 31 0 100meg
R_PD_150 Q 0 100meg
R_PD_151 G35 0 100meg
R_PD_152 27 0 100meg
R_PD_153 G142 0 100meg
R_PD_154 G138 0 100meg
R_PD_155 67 0 100meg
R_PD_156 G111 0 100meg
R_PD_157 G22 0 100meg
R_PD_158 G24 0 100meg
R_PD_159 G211 0 100meg
R_PD_160 13 0 100meg
R_PD_161 G113 0 100meg
R_PD_162 G127 0 100meg
R_PD_163 11 0 100meg
R_PD_164 5 0 100meg

* Transient Simulation Directive
.TRAN 100p 10n
