* Nangila SPICE Auto-Synthesized Netlist
.SUBCKT INV_X1 A Z
M1 Z A 0 0 NMOS W=0.2u L=0.05u
M2 Z A 1 1 PMOS W=0.4u L=0.05u
.ENDS

.SUBCKT NAND2_X1 A1 A2 Z
M1 Z A1 1 1 PMOS W=0.4u L=0.05u
M2 Z A2 1 1 PMOS W=0.4u L=0.05u
M3 Z A1 int 0 NMOS W=0.2u L=0.05u
M4 int A2 0 0 NMOS W=0.2u L=0.05u
.ENDS

.SUBCKT AND2_X1 A1 A2 Z
X1 A1 A2 Z_bar NAND2_X1
X2 Z_bar Z INV_X1
.ENDS

.SUBCKT NOR2_X1 A1 A2 Z
M1 int1 A1 1 1 PMOS W=0.4u L=0.05u
M2 Z A2 int1 1 PMOS W=0.4u L=0.05u
M3 Z A1 0 0 NMOS W=0.2u L=0.05u
M4 Z A2 0 0 NMOS W=0.2u L=0.05u
.ENDS

.SUBCKT OR2_X1 A1 A2 Z
X1 A1 A2 Z_bar NOR2_X1
X2 Z_bar Z INV_X1
.ENDS

.SUBCKT XOR2_X1 A1 A2 Z
X1 A1 A2 int1 AND2_X1
X2 A1 A2 int2 NOR2_X1
X3 int1 int2 int3 NOR2_X1
X4 int3 Z INV_X1
.ENDS

.SUBCKT XNOR2_X1 A B Z
X1 A B Z_int XOR2_X1
X2 Z_int Z INV_X1
.ENDS

.SUBCKT BUF_X1 A Z
X1 A Z_bar INV_X1
X2 Z_bar Z INV_X1
.ENDS

.SUBCKT OAI21_X1 A B C Z
X1 A B C Z_bar AOI21_X1
X2 Z_bar Z INV_X1
.ENDS

.SUBCKT AOI21_X1 A B C Z
M1 Z A int1 1 PMOS W=0.4u L=0.05u
M2 int1 B 1 1 PMOS W=0.4u L=0.05u
M3 Z C 1 1 PMOS W=0.4u L=0.05u
M4 Z A 0 0 NMOS W=0.2u L=0.05u
M5 Z B 0 0 NMOS W=0.2u L=0.05u
M6 Z C 0 0 NMOS W=0.2u L=0.05u
.ENDS

.SUBCKT NAND3_X1 A1 A2 A3 Z
X1 A1 A2 int1 AND2_X1
X2 int1 A3 Z NAND2_X1
.ENDS

.SUBCKT AND3_X1 A1 A2 A3 Z
X1 A1 A2 A3 Z_bar NAND3_X1
X2 Z_bar Z INV_X1
.ENDS

.SUBCKT NOR3_X1 A1 A2 A3 Z
X1 A1 A2 int1 OR2_X1
X2 int1 A3 Z NOR2_X1
.ENDS

.SUBCKT OR3_X1 A1 A2 A3 Z
X1 A1 A2 A3 Z_bar NOR3_X1
X2 Z_bar Z INV_X1
.ENDS

.SUBCKT NAND4_X1 A1 A2 A3 A4 Z
X1 A1 A2 A3 int1 AND3_X1
X2 int1 A4 Z NAND2_X1
.ENDS

.SUBCKT AND4_X1 A1 A2 A3 A4 Z
X1 A1 A2 A3 A4 Z_bar NAND4_X1
X2 Z_bar Z INV_X1
.ENDS

.SUBCKT NOR4_X1 A1 A2 A3 A4 Z
X1 A1 A2 A3 int1 OR3_X1
X2 int1 A4 Z NOR2_X1
.ENDS

.SUBCKT OR4_X1 A1 A2 A3 A4 Z
X1 A1 A2 A3 A4 Z_bar NOR4_X1
X2 Z_bar Z INV_X1
.ENDS

.SUBCKT AOI22_X1 A B C D Z
X1 A B int1 AND2_X1
X2 C D int2 AND2_X1
X3 int1 int2 Z NOR2_X1
.ENDS

.SUBCKT OAI22_X1 A B C D Z
X1 A B int1 OR2_X1
X2 C D int2 OR2_X1
X3 int1 int2 Z NAND2_X1
.ENDS

.SUBCKT AOI211_X1 A B C D Z
X1 A B int1 AND2_X1
X2 int1 C D Z NOR3_X1
.ENDS

.SUBCKT OAI211_X1 A B C D Z
X1 A B int1 OR2_X1
X2 int1 C D Z NAND3_X1
.ENDS

.SUBCKT OAI33_X1 A B C D E F Z
X1 A B C int1 OR3_X1
X2 D E F int2 OR3_X1
X3 int1 int2 Z NAND2_X1
.ENDS

.SUBCKT AOI33_X1 A B C D E F Z
X1 A B C int1 AND3_X1
X2 D E F int2 AND3_X1
X3 int1 int2 Z NOR2_X1
.ENDS

.SUBCKT MUX2_X1 A B S Z
X1 S S_bar INV_X1
X2 A S_bar int1 AND2_X1
X3 B S int2 AND2_X1
X4 int1 int2 Z OR2_X1
.ENDS

.SUBCKT DFF_X1 D C Q QN
X1 D Q_int INV_X1
X2 Q_int Q INV_X1
X3 Q_int QN INV_X1
.ENDS

.SUBCKT DFFR_X1 D C RN Q QN
X1 D Q_int INV_X1
X2 Q_int Q INV_X1
X3 Q_int QN INV_X1
.ENDS

.SUBCKT DFFS_X1 C D Q QN SN
X1 D Q_int INV_X1
X2 Q_int Q INV_X1
X3 Q_int QN INV_X1
.ENDS

.SUBCKT DFFRS_X1 C D Q QN RN SN
X1 D Q_int INV_X1
X2 Q_int Q INV_X1
X3 Q_int QN INV_X1
.ENDS

* Provide VDD power source explicitly
Vvdd 1 0 1.8

* Auto-extracted Inputs:
V_N1 N1 0 1.8
V_N4 N4 0 0.0
V_N11 N11 0 1.8
V_N14 N14 0 0.0
V_N17 N17 0 1.8
V_N20 N20 0 0.0
V_N23 N23 0 1.8
V_N24 N24 0 0.0
V_N25 N25 0 1.8
V_N26 N26 0 0.0
V_N27 N27 0 1.8
V_N31 N31 0 0.0
V_N34 N34 0 1.8
V_N37 N37 0 0.0
V_N40 N40 0 1.8
V_N43 N43 0 0.0
V_N46 N46 0 1.8
V_N49 N49 0 0.0
V_N52 N52 0 1.8
V_N53 N53 0 0.0
V_N54 N54 0 1.8
V_N61 N61 0 0.0
V_N64 N64 0 1.8
V_N67 N67 0 0.0
V_N70 N70 0 1.8
V_N73 N73 0 0.0
V_N76 N76 0 1.8
V_N79 N79 0 0.0
V_N80 N80 0 1.8
V_N81 N81 0 0.0
V_N82 N82 0 1.8
V_N83 N83 0 0.0
V_N86 N86 0 1.8
V_N87 N87 0 0.0
V_N88 N88 0 1.8
V_N91 N91 0 0.0
V_N94 N94 0 1.8
V_N97 N97 0 0.0
V_N100 N100 0 1.8
V_N103 N103 0 0.0
V_N106 N106 0 1.8
V_N109 N109 0 0.0
V_N112 N112 0 1.8
V_N113 N113 0 0.0
V_N114 N114 0 1.8
V_N115 N115 0 0.0
V_N116 N116 0 1.8
V_N117 N117 0 0.0
V_N118 N118 0 1.8
V_N119 N119 0 0.0
V_N120 N120 0 1.8
V_N121 N121 0 0.0
V_N122 N122 0 1.8
V_N123 N123 0 0.0
V_N126 N126 0 1.8
V_N127 N127 0 0.0
V_N128 N128 0 1.8
V_N129 N129 0 0.0
V_N130 N130 0 1.8
V_N131 N131 0 0.0
V_N132 N132 0 1.8
V_N135 N135 0 0.0
V_N136 N136 0 1.8
V_N137 N137 0 0.0
V_N140 N140 0 1.8
V_N141 N141 0 0.0
V_N145 N145 0 1.8
V_N146 N146 0 0.0
V_N149 N149 0 1.8
V_N152 N152 0 0.0
V_N155 N155 0 1.8
V_N158 N158 0 0.0
V_N161 N161 0 1.8
V_N164 N164 0 0.0
V_N167 N167 0 1.8
V_N170 N170 0 0.0
V_N173 N173 0 1.8
V_N176 N176 0 0.0
V_N179 N179 0 1.8
V_N182 N182 0 0.0
V_N185 N185 0 1.8
V_N188 N188 0 0.0
V_N191 N191 0 1.8
V_N194 N194 0 0.0
V_N197 N197 0 1.8
V_N200 N200 0 0.0
V_N203 N203 0 1.8
V_N206 N206 0 0.0
V_N209 N209 0 1.8
V_N210 N210 0 0.0
V_N217 N217 0 1.8
V_N218 N218 0 0.0
V_N225 N225 0 1.8
V_N226 N226 0 0.0
V_N233 N233 0 1.8
V_N234 N234 0 0.0
V_N241 N241 0 1.8
V_N242 N242 0 0.0
V_N245 N245 0 1.8
V_N248 N248 0 0.0
V_N251 N251 0 1.8
V_N254 N254 0 0.0
V_N257 N257 0 1.8
V_N264 N264 0 0.0
V_N265 N265 0 1.8
V_N272 N272 0 0.0
V_N273 N273 0 1.8
V_N280 N280 0 0.0
V_N281 N281 0 1.8
V_N288 N288 0 0.0
V_N289 N289 0 1.8
V_N292 N292 0 0.0
V_N293 N293 0 1.8
V_N299 N299 0 0.0
V_N302 N302 0 1.8
V_N307 N307 0 0.0
V_N308 N308 0 1.8
V_N315 N315 0 0.0
V_N316 N316 0 1.8
V_N323 N323 0 0.0
V_N324 N324 0 1.8
V_N331 N331 0 0.0
V_N332 N332 0 1.8
V_N335 N335 0 0.0
V_N338 N338 0 1.8
V_N341 N341 0 0.0
V_N348 N348 0 1.8
V_N351 N351 0 0.0
V_N358 N358 0 1.8
V_N361 N361 0 0.0
V_N366 N366 0 1.8
V_N369 N369 0 0.0
V_N372 N372 0 1.8
V_N373 N373 0 0.0
V_N374 N374 0 1.8
V_N386 N386 0 0.0
V_N389 N389 0 1.8
V_N400 N400 0 0.0
V_N411 N411 0 1.8
V_N422 N422 0 0.0
V_N435 N435 0 1.8
V_N446 N446 0 0.0
V_N457 N457 0 1.8
V_N468 N468 0 0.0
V_N479 N479 0 1.8
V_N490 N490 0 0.0
V_N503 N503 0 1.8
V_N514 N514 0 0.0
V_N523 N523 0 1.8
V_N534 N534 0 0.0
V_N545 N545 0 1.8
V_N549 N549 0 0.0
V_N552 N552 0 1.8
V_N556 N556 0 0.0
V_N559 N559 0 1.8
V_N562 N562 0 0.0
V_N566 N566 0 1.8
V_N571 N571 0 0.0
V_N574 N574 0 1.8
V_N577 N577 0 0.0
V_N580 N580 0 1.8
V_N583 N583 0 0.0
V_N588 N588 0 1.8
V_N591 N591 0 0.0
V_N592 N592 0 1.8
V_N595 N595 0 0.0
V_N596 N596 0 1.8
V_N597 N597 0 0.0
V_N598 N598 0 1.8
V_N599 N599 0 0.0
V_N603 N603 0 1.8
V_N607 N607 0 0.0
V_N610 N610 0 1.8
V_N613 N613 0 0.0
V_N616 N616 0 1.8
V_N619 N619 0 0.0
V_N625 N625 0 1.8
V_N631 N631 0 0.0

* Yosys Generated Netlist:
* SPICE netlist generated by Yosys 0.62 (git sha1 7326bb7d6641500ecb285c291a54a662cb1e76cf, clang++ 17.0.0 -fPIC -O3)

X0 N552 N1153 INV_X1
X1 N562 N1154 INV_X1
X2 N559 N1155 INV_X1
X3 N136 1 INV_X1
X4 N514 2 INV_X1
X5 N571 3 INV_X1
X6 N574 4 INV_X1
X7 N185 5 INV_X1
X8 N158 6 INV_X1
X9 N152 7 INV_X1
X10 N577 8 INV_X1
X11 N613 9 INV_X1
X12 N616 10 INV_X1
X13 N610 11 INV_X1
X14 N607 12 INV_X1
X15 N619 13 INV_X1
X16 N625 14 INV_X1
X17 N179 15 INV_X1
X18 N457 16 INV_X1
X19 N389 17 INV_X1
X20 N400 18 INV_X1
X21 N335 19 INV_X1
X22 N523 20 INV_X1
X23 N534 21 INV_X1
X24 N332 22 INV_X1
X25 N366 N1139 INV_X1
X26 N358 N1145 INV_X1
X27 N348 N1138 INV_X1
X28 N338 N1144 INV_X1
X29 N299 N3613 INV_X1
X30 N479 23 INV_X1
X31 N490 24 INV_X1
X32 N251 25 INV_X1
X33 N120 26 INV_X1
X34 N118 27 INV_X1
X35 N87 28 INV_X1
X36 N34 29 INV_X1
X37 N24 30 INV_X1
X38 N26 31 INV_X1
X39 N79 32 INV_X1
X40 N82 33 INV_X1
X41 N54 34 INV_X1
X42 N4 35 INV_X1
X43 N137 36 INV_X1
X44 N245 N1152 INV_X1
X45 N566 37 INV_X1
X46 N583 38 INV_X1
X47 N591 39 INV_X1
X48 N598 40 INV_X1
X49 N545 N1137 INV_X1
X50 N549 N1141 INV_X1
X51 N1153 N1154 N1140 NOR2_X1
X52 N373 N1 N1972 AND2_X1
X53 N141 N145 N1147 AND2_X1
X54 1 N592 N2054 NOR2_X1
X55 N27 N31 41 AND2_X1
X56 41 N2623 INV_X1
X57 N2623 N25 N588 42 AOI21_X1
X58 42 30 N588 43 OAI21_X1
X59 N141 43 N4737 AND2_X1
X60 N2623 N81 N588 44 AOI21_X1
X61 44 31 N588 45 OAI21_X1
X62 N141 45 N4738 AND2_X1
X63 N2623 N23 N588 46 AOI21_X1
X64 46 32 N588 47 OAI21_X1
X65 N141 47 N4739 AND2_X1
X66 N2623 N80 N588 48 AOI21_X1
X67 48 33 N588 49 OAI21_X1
X68 N141 49 N4740 AND2_X1
X69 N254 N242 N316 50 MUX2_X1
X70 N490 N316 25 51 OAI21_X1
X71 51 N316 N248 52 AOI21_X1
X72 52 50 24 53 AOI21_X1
X73 N254 N242 N308 54 MUX2_X1
X74 N479 N308 25 55 OAI21_X1
X75 55 N308 N248 56 AOI21_X1
X76 56 54 23 57 AOI21_X1
X77 N324 40 58 NAND2_X1
X78 N596 N595 N324 59 MUX2_X1
X79 N503 58 N597 N324 60 OAI211_X1
X80 60 59 N503 61 OAI21_X1
X81 N251 N248 N302 62 MUX2_X1
X82 N254 N242 N293 63 MUX2_X1
X83 63 64 INV_X1
X84 N251 N248 N361 65 MUX2_X1
X85 N595 40 N514 66 MUX2_X1
X86 62 64 65 66 67 NAND4_X1
X87 N596 N595 N341 68 MUX2_X1
X88 20 N341 40 69 AOI21_X1
X89 69 N597 N341 70 OAI21_X1
X90 70 68 N523 71 OAI21_X1
X91 N596 N595 N351 72 MUX2_X1
X92 21 N351 40 73 AOI21_X1
X93 73 N597 N351 74 OAI21_X1
X94 74 72 N534 75 OAI21_X1
X95 61 67 71 75 76 NOR4_X1
X96 53 57 76 N5240 AND3_X1
X97 N281 40 77 NAND2_X1
X98 N596 N595 N281 78 MUX2_X1
X99 N374 77 N597 N281 79 OAI211_X1
X100 79 78 N374 80 OAI21_X1
X101 N596 N595 N210 81 MUX2_X1
X102 16 N210 40 82 AOI21_X1
X103 82 N597 N210 83 OAI21_X1
X104 83 81 N457 84 OAI21_X1
X105 N226 40 85 NAND2_X1
X106 N596 N595 N226 86 MUX2_X1
X107 N422 85 N597 N226 87 OAI211_X1
X108 87 86 N422 88 OAI21_X1
X109 N218 40 89 NAND2_X1
X110 N596 N595 N218 90 MUX2_X1
X111 N468 89 N597 N218 91 OAI211_X1
X112 91 90 N468 92 OAI21_X1
X113 N251 N248 N206 93 MUX2_X1
X114 N254 N242 N206 94 MUX2_X1
X115 N446 94 95 NOR2_X1
X116 95 93 N446 96 AOI21_X1
X117 92 96 97 NOR2_X1
X118 N596 N595 N265 98 MUX2_X1
X119 18 N265 40 99 AOI21_X1
X120 99 N597 N265 100 OAI21_X1
X121 100 98 N400 101 OAI21_X1
X122 N273 40 102 NAND2_X1
X123 N596 N595 N273 103 MUX2_X1
X124 N411 102 N597 N273 104 OAI211_X1
X125 104 103 N411 105 OAI21_X1
X126 N596 N595 N257 106 MUX2_X1
X127 17 N257 40 107 AOI21_X1
X128 107 N597 N257 108 OAI21_X1
X129 108 106 N389 109 OAI21_X1
X130 N234 40 110 NAND2_X1
X131 110 N597 N234 111 OAI21_X1
X132 N596 N595 N234 112 MUX2_X1
X133 112 111 N435 113 MUX2_X1
X134 80 88 101 109 114 NOR4_X1
X135 97 113 114 115 NAND3_X1
X136 84 105 115 N5388 NOR3_X1
X137 N206 N209 N335 116 MUX2_X1
X138 N446 116 117 NAND2_X1
X139 N446 116 118 XNOR2_X1
X140 N226 N233 N335 119 MUX2_X1
X141 N422 119 120 OR2_X1
X142 N422 119 121 AND2_X1
X143 N422 119 122 XNOR2_X1
X144 N218 N225 N335 123 MUX2_X1
X145 N468 123 124 AND2_X1
X146 N468 123 125 NAND2_X1
X147 N468 123 126 NOR2_X1
X148 N468 123 127 XNOR2_X1
X149 122 127 128 NOR2_X1
X150 N210 N335 129 NOR2_X1
X151 19 N217 130 NOR2_X1
X152 N210 N217 N335 131 MUX2_X1
X153 N457 131 132 NOR2_X1
X154 N457 131 133 XNOR2_X1
X155 122 127 133 134 NOR3_X1
X156 118 122 127 133 135 OR4_X1
X157 N257 N335 136 NOR2_X1
X158 19 N264 137 NOR2_X1
X159 N257 N264 N335 138 MUX2_X1
X160 N389 138 139 AND2_X1
X161 N389 138 140 NOR2_X1
X162 N389 138 141 OR2_X1
X163 N389 138 142 XNOR2_X1
X164 N281 N288 N335 143 MUX2_X1
X165 N374 143 144 AND2_X1
X166 N374 143 145 NOR2_X1
X167 144 145 146 NOR2_X1
X168 N374 143 147 XNOR2_X1
X169 N273 N280 N335 148 MUX2_X1
X170 N411 148 149 AND2_X1
X171 N411 148 150 NAND2_X1
X172 N411 148 151 NOR2_X1
X173 N411 148 152 OR2_X1
X174 N411 148 153 XNOR2_X1
X175 N265 N335 154 NOR2_X1
X176 19 N272 155 NOR2_X1
X177 N265 N272 N335 156 MUX2_X1
X178 N400 156 157 NAND2_X1
X179 N400 156 158 NOR2_X1
X180 N400 156 159 XNOR2_X1
X181 147 153 159 160 NOR3_X1
X182 142 147 153 159 161 OR4_X1
X183 161 162 INV_X1
X184 N234 N241 N335 163 MUX2_X1
X185 N435 163 164 NAND2_X1
X186 N435 163 165 OR2_X1
X187 164 165 166 NAND2_X1
X188 161 166 167 OR2_X1
X189 135 167 N6641 NOR2_X1
X190 N324 N331 N332 168 MUX2_X1
X191 N503 168 169 AND2_X1
X192 N503 168 170 NOR2_X1
X193 169 170 171 NOR2_X1
X194 N341 N332 172 NOR2_X1
X195 22 N348 173 NOR2_X1
X196 N341 N348 N332 174 MUX2_X1
X197 N523 174 175 NOR2_X1
X198 N523 174 176 XNOR2_X1
X199 N351 N358 N332 177 MUX2_X1
X200 N534 177 178 NOR2_X1
X201 N534 177 179 OR2_X1
X202 N534 177 180 XNOR2_X1
X203 N361 N366 N332 181 MUX2_X1
X204 176 180 181 182 NOR3_X1
X205 22 N338 183 NOR2_X1
X206 2 183 184 NOR2_X1
X207 2 183 185 NAND2_X1
X208 N514 183 186 XNOR2_X1
X209 182 186 187 NAND2_X1
X210 171 182 186 188 NAND3_X1
X211 N308 N315 N332 189 MUX2_X1
X212 N479 189 190 AND2_X1
X213 N479 189 191 NAND2_X1
X214 N479 189 192 NOR2_X1
X215 N479 189 193 OR2_X1
X216 N479 189 194 XNOR2_X1
X217 N316 N323 N332 195 MUX2_X1
X218 N490 195 196 AND2_X1
X219 N490 195 197 NOR2_X1
X220 197 198 INV_X1
X221 196 197 199 OR2_X1
X222 N479 189 195 N490 200 AOI22_X1
X223 192 197 201 NOR2_X1
X224 194 199 202 NOR2_X1
X225 202 203 INV_X1
X226 N302 N307 N332 204 MUX2_X1
X227 204 205 INV_X1
X228 N293 N299 N332 206 MUX2_X1
X229 188 203 204 206 N6643 NOR4_X1
X230 N374 143 148 N411 207 OAI211_X1
X231 N374 143 148 N411 208 AOI22_X1
X232 151 158 208 209 OR3_X1
X233 150 157 207 210 AND3_X1
X234 157 208 151 211 OAI21_X1
X235 18 154 155 158 208 151 212 OAI33_X1
X236 141 212 139 213 OAI21_X1
X237 17 136 137 140 158 210 214 OAI33_X1
X238 141 165 212 139 215 OAI211_X1
X239 164 215 216 AND2_X1
X240 164 215 217 NAND2_X1
X241 N422 119 123 N468 218 AOI22_X1
X242 126 218 219 NOR2_X1
X243 16 129 130 132 218 126 220 OAI33_X1
X244 220 116 N446 221 OAI21_X1
X245 117 221 216 135 N6924 OAI211_X1
X246 192 200 222 NOR2_X1
X247 205 200 192 223 OAI21_X1
X248 181 177 N534 224 AOI21_X1
X249 20 172 173 175 178 224 225 OAI33_X1
X250 184 185 225 226 AOI21_X1
X251 169 184 185 225 227 AOI211_X1
X252 170 227 228 NOR2_X1
X253 202 228 229 AND2_X1
X254 206 223 229 N6925 OR3_X1
X255 N619 14 230 NOR2_X1
X256 N4 146 231 NAND2_X1
X257 N4 147 232 XNOR2_X1
X258 13 232 233 NOR2_X1
X259 14 80 N619 234 OAI21_X1
X260 233 234 235 NOR2_X1
X261 235 230 N117 N7365 AOI21_X1
X262 N131 230 236 NAND2_X1
X263 N54 181 237 OR2_X1
X264 34 181 238 XNOR2_X1
X265 65 238 N619 239 MUX2_X1
X266 236 239 N625 240 OAI21_X1
X267 240 N7015 INV_X1
X268 12 240 N610 241 OAI21_X1
X269 241 N7365 N610 242 AOI21_X1
X270 11 12 243 NOR2_X1
X271 N610 12 244 NOR2_X1
X272 242 243 N61 244 N11 245 AOI221_X1
X273 245 N7449 INV_X1
X274 N11 N61 N613 246 MUX2_X1
X275 10 240 N613 247 OAI21_X1
X276 247 N7365 N613 248 AOI21_X1
X277 248 246 N616 249 AOI21_X1
X278 249 N7469 INV_X1
X279 216 167 35 250 OAI21_X1
X280 121 250 120 251 AOI21_X1
X281 127 251 252 XOR2_X1
X282 122 250 253 XOR2_X1
X283 213 161 35 254 OAI21_X1
X284 166 254 255 XOR2_X1
X285 212 160 N4 256 AOI21_X1
X286 142 256 257 XNOR2_X1
X287 151 208 231 153 258 OAI22_X1
X288 159 258 259 XNOR2_X1
X289 259 260 INV_X1
X290 144 146 N4 261 AOI21_X1
X291 153 261 262 XOR2_X1
X292 232 259 262 263 NOR3_X1
X293 253 255 257 263 264 NAND4_X1
X294 219 250 128 265 AOI21_X1
X295 133 265 266 XOR2_X1
X296 220 250 134 267 AOI21_X1
X297 118 267 268 XOR2_X1
X298 252 264 266 268 N7503 NOR4_X1
X299 188 227 170 269 OAI21_X1
X300 34 188 227 170 270 OAI22_X1
X301 222 270 202 271 AOI21_X1
X302 205 271 272 NAND2_X1
X303 206 272 N7432 XOR2_X1
X304 196 198 270 273 AOI21_X1
X305 194 273 274 XOR2_X1
X306 205 222 275 NOR2_X1
X307 205 271 276 XNOR2_X1
X308 199 270 277 XOR2_X1
X309 225 182 N54 278 AOI21_X1
X310 226 187 34 279 OAI21_X1
X311 171 279 280 XNOR2_X1
X312 186 278 281 XOR2_X1
X313 237 177 N534 282 AOI21_X1
X314 178 282 283 NOR2_X1
X315 176 283 284 XOR2_X1
X316 180 206 285 NOR2_X1
X317 238 284 285 286 AND3_X1
X318 277 280 281 286 287 NAND4_X1
X319 274 276 287 N7504 NOR3_X1
X320 N574 N7365 N571 288 AOI21_X1
X321 288 240 N571 289 OAI21_X1
X322 N571 4 290 NOR2_X1
X323 3 4 291 NOR2_X1
X324 N182 290 291 N185 292 AOI22_X1
X325 36 289 292 N7506 AOI21_X1
X326 N577 240 293 NOR2_X1
X327 N580 293 N7365 N577 294 AOI211_X1
X328 N580 N182 N577 295 OAI21_X1
X329 295 N577 5 296 AOI21_X1
X330 N137 294 296 297 OAI21_X1
X331 297 N7511 INV_X1
X332 N619 255 298 NAND2_X1
X333 N625 113 13 299 AOI21_X1
X334 N122 230 298 299 N7470 AOI22_X1
X335 N52 230 300 NAND2_X1
X336 N619 280 301 NAND2_X1
X337 N619 61 302 NOR2_X1
X338 14 301 303 NAND2_X1
X339 300 302 303 304 OAI21_X1
X340 304 N7465 INV_X1
X341 N607 N7470 N610 305 AOI21_X1
X342 305 304 N610 306 OAI21_X1
X343 N37 243 244 N43 307 AOI22_X1
X344 306 307 N7515 NAND2_X1
X345 N130 230 308 AND2_X1
X346 N619 281 309 AND2_X1
X347 N625 309 66 13 310 AOI211_X1
X348 308 310 311 OR2_X1
X349 311 N7466 INV_X1
X350 14 109 N619 312 OAI21_X1
X351 312 257 N619 313 AOI21_X1
X352 313 230 N128 N7471 AOI21_X1
X353 12 311 N610 314 OAI21_X1
X354 314 N7471 N610 315 AOI21_X1
X355 315 244 N76 N20 243 316 AOI221_X1
X356 316 N7516 INV_X1
X357 14 101 N619 317 OAI21_X1
X358 317 260 N619 318 AOI21_X1
X359 318 230 N127 N7472 AOI21_X1
X360 14 71 N619 319 OAI21_X1
X361 319 284 N619 320 AOI21_X1
X362 320 230 N119 N7467 AOI21_X1
X363 N7467 321 INV_X1
X364 12 321 N610 322 OAI21_X1
X365 322 N7472 N610 323 AOI21_X1
X366 323 244 N73 N17 243 324 AOI221_X1
X367 324 N7517 INV_X1
X368 13 262 325 NOR2_X1
X369 14 105 N619 326 OAI21_X1
X370 325 326 327 NOR2_X1
X371 327 230 N126 N7473 AOI21_X1
X372 N129 230 328 NAND2_X1
X373 180 237 329 AND2_X1
X374 N619 180 237 330 OAI21_X1
X375 N619 75 329 330 331 OAI22_X1
X376 328 331 N625 332 OAI21_X1
X377 332 N7363 INV_X1
X378 12 332 N610 333 OAI21_X1
X379 333 N7473 N610 334 AOI21_X1
X380 334 244 N67 N70 243 335 AOI221_X1
X381 335 N7518 INV_X1
X382 9 N37 336 NOR2_X1
X383 N616 N43 N613 337 OAI21_X1
X384 N616 N7470 N613 338 AOI21_X1
X385 338 304 N613 339 OAI21_X1
X386 339 337 336 N7519 OAI21_X1
X387 N613 N76 340 NOR2_X1
X388 N616 N20 9 341 OAI21_X1
X389 N616 N7471 N613 342 AOI21_X1
X390 342 311 N613 343 OAI21_X1
X391 343 341 340 N7520 OAI21_X1
X392 N73 N17 N613 344 MUX2_X1
X393 N613 N7472 345 NAND2_X1
X394 N616 N7467 9 346 AOI21_X1
X395 N616 344 345 346 347 AOI22_X1
X396 347 N7521 INV_X1
X397 N67 N70 N613 348 MUX2_X1
X398 10 332 N613 349 OAI21_X1
X399 349 N7473 N613 350 AOI21_X1
X400 350 348 N616 351 AOI21_X1
X401 351 N7522 INV_X1
X402 N574 N7470 N571 352 AOI21_X1
X403 352 304 N571 353 OAI21_X1
X404 N200 290 291 N170 354 AOI22_X1
X405 36 353 354 N7600 AOI21_X1
X406 N574 N7473 N571 355 AOI21_X1
X407 355 332 N571 356 OAI21_X1
X408 N188 290 291 N158 357 AOI22_X1
X409 36 356 357 N7601 AOI21_X1
X410 4 321 N571 358 OAI21_X1
X411 358 N7472 N571 359 AOI21_X1
X412 359 290 N155 N152 291 360 AOI221_X1
X413 36 360 N7602 NOR2_X1
X414 N574 N7471 N571 361 AOI21_X1
X415 361 311 N571 362 OAI21_X1
X416 N149 290 291 N146 363 AOI22_X1
X417 36 362 363 N7603 AOI21_X1
X418 N577 N200 364 OR2_X1
X419 N580 364 N170 8 365 OAI211_X1
X420 N580 N7470 N577 366 AOI21_X1
X421 366 304 N577 367 OAI21_X1
X422 36 365 367 N7604 AOI21_X1
X423 N580 N188 N577 368 OAI21_X1
X424 368 N577 6 369 AOI21_X1
X425 N577 332 370 NOR2_X1
X426 N580 370 N7473 N577 371 AOI211_X1
X427 N137 369 371 372 OAI21_X1
X428 372 N7605 INV_X1
X429 N580 N155 N577 373 OAI21_X1
X430 373 N577 7 374 AOI21_X1
X431 N577 321 375 NOR2_X1
X432 N580 375 N7472 N577 376 AOI211_X1
X433 N137 374 376 377 OAI21_X1
X434 377 N7606 INV_X1
X435 N577 N149 378 NOR2_X1
X436 N580 8 N146 379 OAI21_X1
X437 N580 N7471 N577 380 AOI21_X1
X438 380 311 N577 381 OAI21_X1
X439 381 379 378 382 OAI21_X1
X440 N137 382 383 NAND2_X1
X441 383 N7607 INV_X1
X442 N132 206 384 XOR2_X1
X443 N599 N603 384 385 AOI21_X1
X444 385 63 N603 386 OAI21_X1
X445 N603 N7432 387 NAND2_X1
X446 N599 387 N603 N123 388 OAI211_X1
X447 N135 N631 386 388 N7626 AOI22_X1
X448 N132 272 N7698 XOR2_X1
X449 204 206 389 XOR2_X1
X450 168 183 390 NOR2_X1
X451 390 183 N331 391 AOI21_X1
X452 389 391 392 XNOR2_X1
X453 174 177 393 XNOR2_X1
X454 N369 N372 N332 394 MUX2_X1
X455 181 394 395 XOR2_X1
X456 189 195 396 XOR2_X1
X457 393 396 397 XNOR2_X1
X458 395 397 398 XNOR2_X1
X459 392 398 N7474 XNOR2_X1
X460 N281 N289 399 XOR2_X1
X461 N234 N257 400 XNOR2_X1
X462 399 400 401 XNOR2_X1
X463 N226 N206 402 XNOR2_X1
X464 N210 N218 403 XNOR2_X1
X465 402 403 404 XNOR2_X1
X466 N265 N273 405 XNOR2_X1
X467 401 405 406 XNOR2_X1
X468 404 406 N6877 XNOR2_X1
X469 N341 N351 407 XOR2_X1
X470 N316 N293 408 XOR2_X1
X471 407 408 409 XNOR2_X1
X472 N302 N308 410 XOR2_X1
X473 N361 410 411 XNOR2_X1
X474 N324 N369 412 XNOR2_X1
X475 409 412 413 XNOR2_X1
X476 411 413 N6716 XNOR2_X1
X477 N386 N556 N2061 NAND2_X1
X478 N559 N245 N1140 414 NAND3_X1
X479 N6877 N2061 414 415 OR3_X1
X480 123 131 416 XNOR2_X1
X481 N289 N292 N335 417 MUX2_X1
X482 163 417 418 XOR2_X1
X483 116 119 419 XNOR2_X1
X484 418 419 420 XNOR2_X1
X485 138 156 421 XOR2_X1
X486 143 148 422 XOR2_X1
X487 421 422 423 XNOR2_X1
X488 416 423 424 XNOR2_X1
X489 420 424 N7476 XNOR2_X1
X490 N7474 N6716 415 N7476 N7703 NOR4_X1
X491 N106 9 425 NOR2_X1
X492 N616 N109 N613 426 OAI21_X1
X493 14 63 N619 427 OAI21_X1
X494 427 N7432 N619 428 AOI21_X1
X495 428 230 N123 N7699 AOI21_X1
X496 N115 230 429 NAND2_X1
X497 N619 96 430 OR2_X1
X498 14 430 268 13 431 OAI211_X1
X499 429 431 N7704 AND2_X1
X500 N7699 N7704 N613 432 MUX2_X1
X501 425 426 432 N616 N7735 OAI22_X1
X502 N7699 N7704 N610 433 MUX2_X1
X503 N106 243 244 N109 434 AOI22_X1
X504 434 433 N607 N7736 OAI21_X1
X505 N114 230 435 NAND2_X1
X506 13 266 436 NOR2_X1
X507 14 84 N619 437 OAI21_X1
X508 435 436 437 438 OAI21_X1
X509 438 N7705 INV_X1
X510 N121 230 439 NAND2_X1
X511 N625 62 13 440 AOI21_X1
X512 440 276 13 441 OAI21_X1
X513 439 441 442 NAND2_X1
X514 442 N7700 INV_X1
X515 N610 442 443 NOR2_X1
X516 12 438 11 444 OAI21_X1
X517 N49 243 244 N46 445 AOI22_X1
X518 445 444 443 N7737 OAI21_X1
X519 N53 230 446 NAND2_X1
X520 N619 92 447 OR2_X1
X521 14 447 252 13 448 OAI211_X1
X522 446 448 N7706 AND2_X1
X523 13 274 449 OR2_X1
X524 N625 57 13 450 AOI21_X1
X525 N116 230 449 450 N7701 AOI22_X1
X526 N7701 451 INV_X1
X527 N7706 N7701 11 452 MUX2_X1
X528 N103 243 244 N100 453 AOI22_X1
X529 453 452 N607 N7738 OAI21_X1
X530 14 88 N619 454 OAI21_X1
X531 454 253 N619 455 AOI21_X1
X532 455 230 N113 N7707 AOI21_X1
X533 N619 277 456 NAND2_X1
X534 N625 53 13 457 AOI21_X1
X535 N112 230 456 457 N7702 AOI22_X1
X536 N7707 N7702 11 458 MUX2_X1
X537 N40 243 244 N91 459 AOI22_X1
X538 459 458 N607 N7739 OAI21_X1
X539 N613 N46 460 NOR2_X1
X540 N616 N49 9 461 OAI21_X1
X541 9 438 462 NOR2_X1
X542 10 442 N613 463 OAI21_X1
X543 460 461 462 463 N7740 OAI22_X1
X544 N100 N103 N613 464 MUX2_X1
X545 N613 N7706 465 NAND2_X1
X546 N616 N7701 9 466 AOI21_X1
X547 N616 464 465 466 467 AOI22_X1
X548 467 N7741 INV_X1
X549 9 N40 468 NOR2_X1
X550 N616 N91 N613 469 OAI21_X1
X551 N7707 N7702 9 470 MUX2_X1
X552 468 469 470 N616 N7742 OAI22_X1
X553 3 N7702 471 NAND2_X1
X554 N574 N7707 N571 472 AOI21_X1
X555 N203 290 471 472 291 N173 473 AOI222_X1
X556 36 473 N7754 NOR2_X1
X557 N574 N7706 N571 474 AOI21_X1
X558 474 451 N571 475 OAI21_X1
X559 N197 290 291 N167 476 AOI22_X1
X560 36 475 476 N7755 AOI21_X1
X561 3 438 477 NOR2_X1
X562 4 442 N571 478 OAI21_X1
X563 N194 290 291 N164 479 AOI22_X1
X564 479 478 477 480 OAI21_X1
X565 N137 480 N7756 AND2_X1
X566 N571 N7704 481 NAND2_X1
X567 N574 N7699 3 482 AOI21_X1
X568 N191 290 481 482 291 N161 483 AOI222_X1
X569 36 483 N7757 NOR2_X1
X570 N173 8 484 NOR2_X1
X571 N580 N203 N577 485 OAI21_X1
X572 N7707 N7702 8 486 MUX2_X1
X573 484 485 486 N580 487 OAI22_X1
X574 N137 487 N7758 AND2_X1
X575 N577 N197 488 OR2_X1
X576 N580 488 N167 8 489 OAI211_X1
X577 N580 N7706 N577 490 AOI21_X1
X578 490 451 N577 491 OAI21_X1
X579 36 489 491 N7759 AOI21_X1
X580 N194 N164 N577 492 MUX2_X1
X581 438 442 8 493 MUX2_X1
X582 493 492 N580 494 MUX2_X1
X583 N137 494 N7760 AND2_X1
X584 N191 N161 N577 495 MUX2_X1
X585 N577 N7704 496 NAND2_X1
X586 N580 N7699 8 497 AOI21_X1
X587 N580 495 496 497 498 AOI22_X1
X588 36 498 N7761 NOR2_X1
X589 194 389 499 XNOR2_X1
X590 198 499 500 XNOR2_X1
X591 275 500 501 XNOR2_X1
X592 228 501 502 OR2_X1
X593 269 501 503 OR2_X1
X594 193 191 197 504 MUX2_X1
X595 190 193 197 204 505 NOR4_X1
X596 505 504 223 200 201 506 AOI221_X1
X597 199 499 507 XNOR2_X1
X598 506 507 508 XNOR2_X1
X599 N583 228 508 509 AOI21_X1
X600 502 509 510 AND2_X1
X601 38 269 508 511 AOI21_X1
X602 503 511 512 AND2_X1
X603 502 509 511 503 513 AOI22_X1
X604 179 182 225 514 OAI21_X1
X605 179 225 515 OR2_X1
X606 178 182 225 516 OR3_X1
X607 178 225 517 NAND2_X1
X608 187 226 514 515 518 AND4_X1
X609 187 226 514 515 519 AOI22_X1
X610 181 518 519 520 OR3_X1
X611 224 181 179 521 AOI21_X1
X612 225 521 522 XOR2_X1
X613 226 522 523 XNOR2_X1
X614 226 522 524 XOR2_X1
X615 38 181 524 525 AOI21_X1
X616 187 226 516 517 526 AOI22_X1
X617 187 226 516 517 527 AND4_X1
X618 181 526 527 528 OR3_X1
X619 181 523 529 XNOR2_X1
X620 181 524 530 XNOR2_X1
X621 38 181 523 531 AOI21_X1
X622 176 180 532 XOR2_X1
X623 171 186 533 XOR2_X1
X624 532 533 534 XNOR2_X1
X625 532 533 535 XOR2_X1
X626 535 525 520 38 530 536 AOI221_X1
X627 534 531 528 38 529 537 AOI221_X1
X628 535 531 528 38 529 538 AOI221_X1
X629 534 525 520 38 530 539 AOI221_X1
X630 513 538 539 540 NOR3_X1
X631 510 512 536 537 541 NOR4_X1
X632 N619 540 541 542 OAI21_X1
X633 N514 N248 543 NAND2_X1
X634 543 N242 N514 544 OAI21_X1
X635 65 544 545 XNOR2_X1
X636 N251 N248 N324 546 MUX2_X1
X637 N254 N242 N324 547 MUX2_X1
X638 N503 547 548 NOR2_X1
X639 548 546 N503 549 AOI21_X1
X640 545 549 550 XNOR2_X1
X641 N254 N242 N351 551 MUX2_X1
X642 N534 N351 25 552 OAI21_X1
X643 552 N248 N351 553 AOI21_X1
X644 553 551 21 554 AOI21_X1
X645 N251 N248 N341 555 MUX2_X1
X646 N254 N242 N341 556 MUX2_X1
X647 N523 556 557 NOR2_X1
X648 557 555 N523 558 AOI21_X1
X649 554 558 559 XNOR2_X1
X650 550 559 560 XNOR2_X1
X651 53 57 561 XOR2_X1
X652 62 63 562 XNOR2_X1
X653 561 562 563 XNOR2_X1
X654 560 563 564 XNOR2_X1
X655 13 564 565 NAND2_X1
X656 N625 542 565 566 AOI21_X1
X657 566 230 26 N8075 AOI21_X1
X658 144 209 211 567 AOI21_X1
X659 144 209 211 568 AND3_X1
X660 214 567 568 569 OR3_X1
X661 214 567 568 570 OAI21_X1
X662 569 570 571 NAND2_X1
X663 153 166 572 XOR2_X1
X664 572 573 INV_X1
X665 146 572 574 XNOR2_X1
X666 37 571 574 575 OAI21_X1
X667 575 574 571 576 AOI21_X1
X668 151 149 145 577 MUX2_X1
X669 152 150 145 578 MUX2_X1
X670 160 212 578 579 OR3_X1
X671 578 212 160 580 OAI21_X1
X672 577 212 160 581 OAI21_X1
X673 160 212 577 582 OR3_X1
X674 581 582 162 214 583 OAI211_X1
X675 161 213 579 580 584 NAND4_X1
X676 146 569 570 585 AOI21_X1
X677 147 583 584 586 AOI21_X1
X678 573 585 586 587 OAI21_X1
X679 573 585 586 588 OR3_X1
X680 37 587 588 589 AOI21_X1
X681 118 133 590 XOR2_X1
X682 118 133 591 XNOR2_X1
X683 121 125 592 NAND2_X1
X684 120 125 126 121 593 OAI211_X1
X685 593 126 120 594 OAI21_X1
X686 220 590 595 XNOR2_X1
X687 594 595 596 XNOR2_X1
X688 164 167 215 597 NAND3_X1
X689 134 220 598 NOR2_X1
X690 121 124 599 NAND2_X1
X691 120 121 124 600 MUX2_X1
X692 218 126 120 601 OAI21_X1
X693 591 599 601 602 NAND3_X1
X694 590 592 600 126 603 OAI211_X1
X695 598 602 603 604 AOI21_X1
X696 598 602 603 605 AND3_X1
X697 216 604 605 606 NOR3_X1
X698 604 605 167 216 607 AOI211_X1
X699 N566 596 597 608 OAI21_X1
X700 37 217 596 609 OAI21_X1
X701 607 608 609 606 610 OAI22_X1
X702 142 159 611 XOR2_X1
X703 610 611 612 XNOR2_X1
X704 612 589 576 613 OAI21_X1
X705 576 589 612 614 OR3_X1
X706 N619 613 614 615 AND3_X1
X707 N619 613 614 616 NAND3_X1
X708 N254 N242 N265 617 MUX2_X1
X709 N400 N265 25 618 OAI21_X1
X710 618 N248 N265 619 AOI21_X1
X711 619 617 18 620 AOI21_X1
X712 N251 N248 N281 621 MUX2_X1
X713 N254 N242 N281 622 MUX2_X1
X714 N374 622 623 NOR2_X1
X715 623 621 N374 624 AOI21_X1
X716 N251 N248 N273 625 MUX2_X1
X717 N254 N242 N273 626 MUX2_X1
X718 N411 626 627 NOR2_X1
X719 627 625 N411 628 AOI21_X1
X720 624 628 629 XNOR2_X1
X721 620 629 630 XNOR2_X1
X722 N251 N248 N218 631 MUX2_X1
X723 N254 N242 N218 632 MUX2_X1
X724 N468 632 633 NOR2_X1
X725 633 631 N468 634 AOI21_X1
X726 96 634 635 XNOR2_X1
X727 630 635 636 XNOR2_X1
X728 N254 N242 N210 637 MUX2_X1
X729 N457 N210 25 638 OAI21_X1
X730 638 N248 N210 639 AOI21_X1
X731 639 637 16 640 AOI21_X1
X732 N251 N248 N226 641 MUX2_X1
X733 N254 N242 N226 642 MUX2_X1
X734 N422 642 643 NOR2_X1
X735 643 641 N422 644 AOI21_X1
X736 640 644 645 XNOR2_X1
X737 N251 N248 N257 646 MUX2_X1
X738 N254 N242 N257 647 MUX2_X1
X739 N389 647 648 NOR2_X1
X740 648 646 N389 649 AOI21_X1
X741 N251 N248 N234 650 MUX2_X1
X742 N254 N242 N234 651 MUX2_X1
X743 N435 651 652 NOR2_X1
X744 652 650 N435 653 AOI21_X1
X745 649 653 654 XNOR2_X1
X746 645 654 655 XNOR2_X1
X747 636 655 656 XNOR2_X1
X748 N625 656 13 657 AOI21_X1
X749 657 658 INV_X1
X750 27 230 616 657 N8076 AOI22_X1
X751 N625 N94 659 AND2_X1
X752 566 659 660 OR2_X1
X753 N610 660 661 NOR2_X1
X754 N625 N97 662 AND2_X1
X755 N625 N97 663 NAND2_X1
X756 663 658 615 664 OAI21_X1
X757 12 664 11 665 OAI21_X1
X758 N64 243 244 N14 666 AOI22_X1
X759 666 665 661 N8123 OAI21_X1
X760 N613 N14 667 NOR2_X1
X761 N616 N64 9 668 OAI21_X1
X762 N613 660 669 NOR2_X1
X763 10 664 9 670 OAI21_X1
X764 667 668 669 670 N8124 OAI22_X1
X765 N140 41 N2590 NAND2_X1
X766 N27 39 N2060 NAND2_X1
X767 N2623 28 N588 671 AOI21_X1
X768 671 N588 N86 N4272 OAI21_X1
X769 N2623 29 N588 672 AOI21_X1
X770 672 N588 N88 N4275 OAI21_X1
X771 N83 41 N4279 NAND2_X1
X772 3 662 657 616 673 AOI211_X1
X773 N571 566 659 674 NOR3_X1
X774 N574 673 674 675 NOR3_X1
X775 N176 290 291 N179 676 AOI22_X1
X776 676 677 INV_X1
X777 N137 675 677 N8127 OAI21_X1
X778 N580 N176 N577 678 OAI21_X1
X779 678 15 N577 679 AOI21_X1
X780 8 662 657 616 680 AOI211_X1
X781 N577 566 659 681 NOR3_X1
X782 N580 680 681 682 NOR3_X1
X783 N137 679 682 N8128 OAI21_X1
X784 188 203 204 206 N6646 NOR4_X1
X785 135 167 N6648 NOR2_X1
X786 117 221 216 135 N6926 OAI211_X1
X787 206 223 229 N6927 OR3_X1
V0 Vss N5726 DC 0
V1 N4275 N4278 DC 0
V2 N616 N1743 DC 0
V3 N613 N1731 DC 0
V4 N619 N1727 DC 0
V5 N625 N1721 DC 0
V6 N607 N1709 DC 0
V7 N610 N1697 DC 0
V8 N254 N1685 DC 0
V9 N588 N2964 DC 0
V10 N242 N1675 DC 0
V11 N242 N1663 DC 0
V12 N234 N1657 DC 0
V13 N234 N1654 DC 0
V14 N226 N1651 DC 0
V15 N226 N1648 DC 0
V16 N218 N1645 DC 0
V17 N6716 N6466 DC 0
V18 N218 N1642 DC 0
V19 N210 N1639 DC 0
V20 N210 N1636 DC 0
V21 N361 N1633 DC 0
V22 N361 N1630 DC 0
V23 N316 N1627 DC 0
V24 N316 N1624 DC 0
V25 N308 N1621 DC 0
V26 N308 N1618 DC 0
V27 N6877 N6724 DC 0
V28 N302 N1615 DC 0
V29 N293 N1612 DC 0
V30 N351 N1609 DC 0
V31 N351 N1606 DC 0
V32 N341 N1603 DC 0
V33 N341 N1600 DC 0
V34 N324 N1597 DC 0
V35 N324 N1594 DC 0
V36 N549 N1580 DC 0
V37 N332 N1573 DC 0
V38 N332 N1566 DC 0
V39 N281 N1563 DC 0
V40 N281 N1560 DC 0
V41 N141 N709 DC 0
V42 N273 N1557 DC 0
V43 N7474 N7394 DC 0
V44 N7476 N7397 DC 0
V45 N7432 N7431 DC 0
V46 N273 N1554 DC 0
V47 N2623 N2891 DC 0
V48 N206 N3000 DC 0
V49 N206 N3003 DC 0
V50 N206 N3007 DC 0
V51 N206 N3010 DC 0
V52 N141 N2877 DC 0
V53 N265 N1551 DC 0
V54 N265 N1548 DC 0
V55 N257 N1545 DC 0
V56 N257 N1542 DC 0
V57 N619 N1761 DC 0
V58 N625 N1769 DC 0
V59 N619 N1777 DC 0
V60 N625 N1785 DC 0
V61 N619 N1793 DC 0
V62 N625 N1800 DC 0
V63 N619 N1807 DC 0
V64 N351 N1525 DC 0
V65 N625 N1814 DC 0
V66 N351 N1522 DC 0
V67 N341 N1519 DC 0
V68 N341 N1516 DC 0
V69 N299 N1821 DC 0
V70 N446 N1824 DC 0
V71 N457 N1827 DC 0
V72 N324 N1513 DC 0
V73 N324 N1510 DC 0
V74 N316 N1507 DC 0
V75 N316 N1504 DC 0
V76 N308 N1501 DC 0
V77 N308 N1498 DC 0
V78 N302 N1495 DC 0
V79 N468 N1830 DC 0
V80 N293 N1492 DC 0
V81 N588 N1482 DC 0
V82 N1 N1479 DC 0
V83 N299 N3191 DC 0
V84 N206 N1469 DC 0
V85 N335 N1462 DC 0
V86 N335 N1455 DC 0
V87 N206 N3200 DC 0
V88 N281 N1436 DC 0
V89 N1 N3357 DC 0
V90 N1 N3358 DC 0
V91 N1 N3359 DC 0
V92 N1 N3360 DC 0
V93 N422 N1833 DC 0
V94 N435 N1836 DC 0
V95 N389 N1839 DC 0
V96 N400 N1842 DC 0
V97 N411 N1845 DC 0
V98 N374 N1848 DC 0
V99 N4 N1851 DC 0
V100 N446 N1854 DC 0
V101 N457 N1857 DC 0
V102 N468 N1860 DC 0
V103 N435 N1863 DC 0
V104 N389 N1866 DC 0
V105 N400 N1869 DC 0
V106 N411 N1872 DC 0
V107 N422 N1875 DC 0
V108 N374 N1878 DC 0
V109 N479 N1881 DC 0
V110 N490 N1884 DC 0
V111 N503 N1887 DC 0
V112 N514 N1890 DC 0
V113 N523 N1893 DC 0
V114 N534 N1896 DC 0
V115 N54 N1899 DC 0
V116 N479 N1902 DC 0
V117 N503 N1905 DC 0
V118 N514 N1908 DC 0
V119 N523 N1911 DC 0
V120 N534 N1914 DC 0
V121 N490 N1917 DC 0
V122 N361 N1920 DC 0
V123 N369 N1923 DC 0
V124 N341 N1926 DC 0
V125 N351 N1929 DC 0
V126 N308 N1932 DC 0
V127 N316 N1935 DC 0
V128 N293 N1938 DC 0
V129 N302 N1941 DC 0
V130 N281 N1944 DC 0
V131 N289 N1947 DC 0
V132 N265 N1950 DC 0
V133 N281 N1433 DC 0
V134 N273 N1430 DC 0
V135 N273 N1427 DC 0
V136 N265 N1424 DC 0
V137 N273 N1953 DC 0
V138 N324 N3780 DC 0
V139 N234 N1956 DC 0
V140 N257 N1959 DC 0
V141 N218 N1962 DC 0
V142 N226 N1965 DC 0
V143 N210 N1968 DC 0
V144 N137 N2139 DC 0
V145 N141 N2142 DC 0
V146 N299 N3604 DC 0
V147 N1 N2309 DC 0
V148 N549 N2387 DC 0
V149 N324 N3779 DC 0
V150 N265 N1421 DC 0
V151 N299 N2527 DC 0
V152 N1141 N2584 DC 0
V153 N1137 N1142 DC 0
V154 N1137 N1143 DC 0
V155 N257 N1418 DC 0
V156 N257 N1415 DC 0
V157 N592 N1066 DC 0
V158 N571 N1161 DC 0
V159 N574 N1173 DC 0
V160 N571 N1185 DC 0
V161 N574 N1197 DC 0
V162 N137 N1209 DC 0
V163 N137 N1213 DC 0
V164 N141 N1216 DC 0
V165 N577 N1223 DC 0
V166 N580 N1235 DC 0
V167 N577 N1247 DC 0
V168 N580 N1259 DC 0
V169 N254 N1271 DC 0
V170 N251 N1280 DC 0
V171 N251 N1292 DC 0
V172 N248 N1303 DC 0
V173 N248 N1315 DC 0
V174 N610 N1327 DC 0
V175 N234 N1396 DC 0
V176 N234 N1393 DC 0
V177 N137 N2647 DC 0
V178 N607 N1339 DC 0
V179 N137 N2675 DC 0
V180 N613 N1351 DC 0
V181 N1 N2704 DC 0
V182 N616 N1363 DC 0
V183 N210 N1375 DC 0
V184 N210 N1378 DC 0
V185 N218 N1381 DC 0
V186 N218 N1384 DC 0
V187 N137 N2750 DC 0
V188 N226 N1390 DC 0
V189 N226 N1387 DC 0
V190 N137 N2722 DC 0
V191 N293 N816 DC 0

************************
* end of SPICE netlist *
************************

* Anti-Floating Pull-Downs (GMIN)
R_PD_0 N2054 0 100meg
R_PD_1 96 0 100meg
R_PD_2 177 0 100meg
R_PD_3 187 0 100meg
R_PD_4 413 0 100meg
R_PD_5 N137 0 100meg
R_PD_6 157 0 100meg
R_PD_7 443 0 100meg
R_PD_8 559 0 100meg
R_PD_9 275 0 100meg
R_PD_10 117 0 100meg
R_PD_11 38 0 100meg
R_PD_12 468 0 100meg
R_PD_13 573 0 100meg
R_PD_14 N116 0 100meg
R_PD_15 N146 0 100meg
R_PD_16 398 0 100meg
R_PD_17 225 0 100meg
R_PD_18 259 0 100meg
R_PD_19 472 0 100meg
R_PD_20 N14 0 100meg
R_PD_21 330 0 100meg
R_PD_22 109 0 100meg
R_PD_23 471 0 100meg
R_PD_24 363 0 100meg
R_PD_25 N200 0 100meg
R_PD_26 596 0 100meg
R_PD_27 72 0 100meg
R_PD_28 N3613 0 100meg
R_PD_29 617 0 100meg
R_PD_30 313 0 100meg
R_PD_31 652 0 100meg
R_PD_32 512 0 100meg
R_PD_33 161 0 100meg
R_PD_34 304 0 100meg
R_PD_35 76 0 100meg
R_PD_36 600 0 100meg
R_PD_37 N610 0 100meg
R_PD_38 501 0 100meg
R_PD_39 211 0 100meg
R_PD_40 200 0 100meg
R_PD_41 229 0 100meg
R_PD_42 N552 0 100meg
R_PD_43 N7518 0 100meg
R_PD_44 N136 0 100meg
R_PD_45 N7467 0 100meg
R_PD_46 239 0 100meg
R_PD_47 502 0 100meg
R_PD_48 485 0 100meg
R_PD_49 594 0 100meg
R_PD_50 N7015 0 100meg
R_PD_51 560 0 100meg
R_PD_52 N234 0 100meg
R_PD_53 383 0 100meg
R_PD_54 354 0 100meg
R_PD_55 102 0 100meg
R_PD_56 52 0 100meg
R_PD_57 127 0 100meg
R_PD_58 321 0 100meg
R_PD_59 557 0 100meg
R_PD_60 43 0 100meg
R_PD_61 242 0 100meg
R_PD_62 135 0 100meg
R_PD_63 N588 0 100meg
R_PD_64 222 0 100meg
R_PD_65 563 0 100meg
R_PD_66 61 0 100meg
R_PD_67 625 0 100meg
R_PD_68 324 0 100meg
R_PD_69 215 0 100meg
R_PD_70 648 0 100meg
R_PD_71 N299 0 100meg
R_PD_72 N351 0 100meg
R_PD_73 464 0 100meg
R_PD_74 612 0 100meg
R_PD_75 48 0 100meg
R_PD_76 228 0 100meg
R_PD_77 529 0 100meg
R_PD_78 N361 0 100meg
R_PD_79 350 0 100meg
R_PD_80 N7755 0 100meg
R_PD_81 N302 0 100meg
R_PD_82 106 0 100meg
R_PD_83 58 0 100meg
R_PD_84 230 0 100meg
R_PD_85 260 0 100meg
R_PD_86 N7522 0 100meg
R_PD_87 10 0 100meg
R_PD_88 N2060 0 100meg
R_PD_89 551 0 100meg
R_PD_90 N7469 0 100meg
R_PD_91 437 0 100meg
R_PD_92 N209 0 100meg
R_PD_93 N100 0 100meg
R_PD_94 N2590 0 100meg
R_PD_95 N210 0 100meg
R_PD_96 N7365 0 100meg
R_PD_97 N468 0 100meg
R_PD_98 545 0 100meg
R_PD_99 56 0 100meg
R_PD_100 N389 0 100meg
R_PD_101 68 0 100meg
R_PD_102 528 0 100meg
R_PD_103 208 0 100meg
R_PD_104 424 0 100meg
R_PD_105 589 0 100meg
R_PD_106 37 0 100meg
R_PD_107 134 0 100meg
R_PD_108 406 0 100meg
R_PD_109 N254 0 100meg
R_PD_110 3 0 100meg
R_PD_111 523 0 100meg
R_PD_112 20 0 100meg
R_PD_113 276 0 100meg
R_PD_114 622 0 100meg
R_PD_115 404 0 100meg
R_PD_116 549 0 100meg
R_PD_117 565 0 100meg
R_PD_118 307 0 100meg
R_PD_119 396 0 100meg
R_PD_120 416 0 100meg
R_PD_121 539 0 100meg
R_PD_122 N20 0 100meg
R_PD_123 530 0 100meg
R_PD_124 355 0 100meg
R_PD_125 N167 0 100meg
R_PD_126 214 0 100meg
R_PD_127 671 0 100meg
R_PD_128 N194 0 100meg
R_PD_129 N82 0 100meg
R_PD_130 165 0 100meg
R_PD_131 271 0 100meg
R_PD_132 504 0 100meg
R_PD_133 180 0 100meg
R_PD_134 N7474 0 100meg
R_PD_135 142 0 100meg
R_PD_136 151 0 100meg
R_PD_137 364 0 100meg
R_PD_138 483 0 100meg
R_PD_139 556 0 100meg
R_PD_140 302 0 100meg
R_PD_141 N79 0 100meg
R_PD_142 17 0 100meg
R_PD_143 503 0 100meg
R_PD_144 519 0 100meg
R_PD_145 N97 0 100meg
R_PD_146 166 0 100meg
R_PD_147 36 0 100meg
R_PD_148 343 0 100meg
R_PD_149 N7756 0 100meg
R_PD_150 138 0 100meg
R_PD_151 202 0 100meg
R_PD_152 N23 0 100meg
R_PD_153 N372 0 100meg
R_PD_154 638 0 100meg
R_PD_155 467 0 100meg
R_PD_156 476 0 100meg
R_PD_157 322 0 100meg
R_PD_158 N37 0 100meg
R_PD_159 257 0 100meg
R_PD_160 261 0 100meg
R_PD_161 236 0 100meg
R_PD_162 658 0 100meg
R_PD_163 325 0 100meg
R_PD_164 53 0 100meg
R_PD_165 59 0 100meg
R_PD_166 514 0 100meg
R_PD_167 N323 0 100meg
R_PD_168 113 0 100meg
R_PD_169 N217 0 100meg
R_PD_170 310 0 100meg
R_PD_171 N106 0 100meg
R_PD_172 613 0 100meg
R_PD_173 128 0 100meg
R_PD_174 369 0 100meg
R_PD_175 287 0 100meg
R_PD_176 318 0 100meg
R_PD_177 N94 0 100meg
R_PD_178 548 0 100meg
R_PD_179 125 0 100meg
R_PD_180 365 0 100meg
R_PD_181 616 0 100meg
R_PD_182 N114 0 100meg
R_PD_183 516 0 100meg
R_PD_184 255 0 100meg
R_PD_185 92 0 100meg
R_PD_186 N17 0 100meg
R_PD_187 22 0 100meg
R_PD_188 409 0 100meg
R_PD_189 475 0 100meg
R_PD_190 550 0 100meg
R_PD_191 509 0 100meg
R_PD_192 44 0 100meg
R_PD_193 71 0 100meg
R_PD_194 558 0 100meg
R_PD_195 256 0 100meg
R_PD_196 262 0 100meg
R_PD_197 632 0 100meg
R_PD_198 41 0 100meg
R_PD_199 N128 0 100meg
R_PD_200 209 0 100meg
R_PD_201 130 0 100meg
R_PD_202 N307 0 100meg
R_PD_203 152 0 100meg
R_PD_204 104 0 100meg
R_PD_205 577 0 100meg
R_PD_206 N369 0 100meg
R_PD_207 N7471 0 100meg
R_PD_208 492 0 100meg
R_PD_209 N571 0 100meg
R_PD_210 111 0 100meg
R_PD_211 237 0 100meg
R_PD_212 277 0 100meg
R_PD_213 N129 0 100meg
R_PD_214 N197 0 100meg
R_PD_215 634 0 100meg
R_PD_216 243 0 100meg
R_PD_217 31 0 100meg
R_PD_218 547 0 100meg
R_PD_219 445 0 100meg
R_PD_220 649 0 100meg
R_PD_221 159 0 100meg
R_PD_222 672 0 100meg
R_PD_223 389 0 100meg
R_PD_224 465 0 100meg
R_PD_225 27 0 100meg
R_PD_226 682 0 100meg
R_PD_227 78 0 100meg
R_PD_228 323 0 100meg
R_PD_229 366 0 100meg
R_PD_230 611 0 100meg
R_PD_231 13 0 100meg
R_PD_232 381 0 100meg
R_PD_233 N2623 0 100meg
R_PD_234 346 0 100meg
R_PD_235 N7699 0 100meg
R_PD_236 178 0 100meg
R_PD_237 N182 0 100meg
R_PD_238 N514 0 100meg
R_PD_239 524 0 100meg
R_PD_240 568 0 100meg
R_PD_241 659 0 100meg
R_PD_242 655 0 100meg
R_PD_243 678 0 100meg
R_PD_244 484 0 100meg
R_PD_245 N6646 0 100meg
R_PD_246 162 0 100meg
R_PD_247 517 0 100meg
R_PD_248 405 0 100meg
R_PD_249 N173 0 100meg
R_PD_250 300 0 100meg
R_PD_251 N130 0 100meg
R_PD_252 386 0 100meg
R_PD_253 253 0 100meg
R_PD_254 N457 0 100meg
R_PD_255 21 0 100meg
R_PD_256 269 0 100meg
R_PD_257 382 0 100meg
R_PD_258 342 0 100meg
R_PD_259 N281 0 100meg
R_PD_260 169 0 100meg
R_PD_261 331 0 100meg
R_PD_262 N140 0 100meg
R_PD_263 357 0 100meg
R_PD_264 N4 0 100meg
R_PD_265 N7520 0 100meg
R_PD_266 440 0 100meg
R_PD_267 562 0 100meg
R_PD_268 452 0 100meg
R_PD_269 65 0 100meg
R_PD_270 N53 0 100meg
R_PD_271 597 0 100meg
R_PD_272 N109 0 100meg
R_PD_273 327 0 100meg
R_PD_274 N523 0 100meg
R_PD_275 87 0 100meg
R_PD_276 470 0 100meg
R_PD_277 280 0 100meg
R_PD_278 344 0 100meg
R_PD_279 477 0 100meg
R_PD_280 136 0 100meg
R_PD_281 498 0 100meg
R_PD_282 598 0 100meg
R_PD_283 N5388 0 100meg
R_PD_284 668 0 100meg
R_PD_285 N115 0 100meg
R_PD_286 466 0 100meg
R_PD_287 N577 0 100meg
R_PD_288 586 0 100meg
R_PD_289 N400 0 100meg
R_PD_290 232 0 100meg
R_PD_291 N2061 0 100meg
R_PD_292 500 0 100meg
R_PD_293 N7705 0 100meg
R_PD_294 244 0 100meg
R_PD_295 N341 0 100meg
R_PD_296 66 0 100meg
R_PD_297 580 0 100meg
R_PD_298 N613 0 100meg
R_PD_299 615 0 100meg
R_PD_300 51 0 100meg
R_PD_301 349 0 100meg
R_PD_302 415 0 100meg
R_PD_303 N4275 0 100meg
R_PD_304 407 0 100meg
R_PD_305 26 0 100meg
R_PD_306 279 0 100meg
R_PD_307 N132 0 100meg
R_PD_308 339 0 100meg
R_PD_309 554 0 100meg
R_PD_310 107 0 100meg
R_PD_311 1 0 100meg
R_PD_312 100 0 100meg
R_PD_313 301 0 100meg
R_PD_314 N6877 0 100meg
R_PD_315 N7738 0 100meg
R_PD_316 N8127 0 100meg
R_PD_317 525 0 100meg
R_PD_318 N1141 0 100meg
R_PD_319 235 0 100meg
R_PD_320 N7511 0 100meg
R_PD_321 662 0 100meg
R_PD_322 544 0 100meg
R_PD_323 116 0 100meg
R_PD_324 N1155 0 100meg
R_PD_325 N6643 0 100meg
R_PD_326 267 0 100meg
R_PD_327 372 0 100meg
R_PD_328 N120 0 100meg
R_PD_329 N152 0 100meg
R_PD_330 N446 0 100meg
R_PD_331 425 0 100meg
R_PD_332 601 0 100meg
R_PD_333 420 0 100meg
R_PD_334 N6926 0 100meg
R_PD_335 293 0 100meg
R_PD_336 N123 0 100meg
R_PD_337 N7703 0 100meg
R_PD_338 591 0 100meg
R_PD_339 144 0 100meg
R_PD_340 584 0 100meg
R_PD_341 89 0 100meg
R_PD_342 N7740 0 100meg
R_PD_343 153 0 100meg
R_PD_344 332 0 100meg
R_PD_345 N1145 0 100meg
R_PD_346 121 0 100meg
R_PD_347 149 0 100meg
R_PD_348 97 0 100meg
R_PD_349 N7700 0 100meg
R_PD_350 N46 0 100meg
R_PD_351 N289 0 100meg
R_PD_352 495 0 100meg
R_PD_353 15 0 100meg
R_PD_354 314 0 100meg
R_PD_355 238 0 100meg
R_PD_356 623 0 100meg
R_PD_357 4 0 100meg
R_PD_358 N1 0 100meg
R_PD_359 574 0 100meg
R_PD_360 455 0 100meg
R_PD_361 360 0 100meg
R_PD_362 N176 0 100meg
R_PD_363 375 0 100meg
R_PD_364 592 0 100meg
R_PD_365 N179 0 100meg
R_PD_366 433 0 100meg
R_PD_367 N583 0 100meg
R_PD_368 201 0 100meg
R_PD_369 7 0 100meg
R_PD_370 N619 0 100meg
R_PD_371 231 0 100meg
R_PD_372 246 0 100meg
R_PD_373 419 0 100meg
R_PD_374 442 0 100meg
R_PD_375 207 0 100meg
R_PD_376 150 0 100meg
R_PD_377 370 0 100meg
R_PD_378 N8128 0 100meg
R_PD_379 408 0 100meg
R_PD_380 337 0 100meg
R_PD_381 N64 0 100meg
R_PD_382 665 0 100meg
R_PD_383 520 0 100meg
R_PD_384 N61 0 100meg
R_PD_385 N225 0 100meg
R_PD_386 254 0 100meg
R_PD_387 473 0 100meg
R_PD_388 306 0 100meg
R_PD_389 417 0 100meg
R_PD_390 N155 0 100meg
R_PD_391 316 0 100meg
R_PD_392 263 0 100meg
R_PD_393 192 0 100meg
R_PD_394 309 0 100meg
R_PD_395 395 0 100meg
R_PD_396 399 0 100meg
R_PD_397 579 0 100meg
R_PD_398 N242 0 100meg
R_PD_399 N6641 0 100meg
R_PD_400 298 0 100meg
R_PD_401 34 0 100meg
R_PD_402 N292 0 100meg
R_PD_403 219 0 100meg
R_PD_404 393 0 100meg
R_PD_405 614 0 100meg
R_PD_406 581 0 100meg
R_PD_407 N40 0 100meg
R_PD_408 N1154 0 100meg
R_PD_409 N233 0 100meg
R_PD_410 367 0 100meg
R_PD_411 N422 0 100meg
R_PD_412 543 0 100meg
R_PD_413 N1152 0 100meg
R_PD_414 N264 0 100meg
R_PD_415 241 0 100meg
R_PD_416 N479 0 100meg
R_PD_417 290 0 100meg
R_PD_418 N324 0 100meg
R_PD_419 N435 0 100meg
R_PD_420 426 0 100meg
R_PD_421 639 0 100meg
R_PD_422 299 0 100meg
R_PD_423 603 0 100meg
R_PD_424 534 0 100meg
R_PD_425 245 0 100meg
R_PD_426 172 0 100meg
R_PD_427 673 0 100meg
R_PD_428 N366 0 100meg
R_PD_429 223 0 100meg
R_PD_430 190 0 100meg
R_PD_431 461 0 100meg
R_PD_432 531 0 100meg
R_PD_433 538 0 100meg
R_PD_434 N265 0 100meg
R_PD_435 252 0 100meg
R_PD_436 438 0 100meg
R_PD_437 88 0 100meg
R_PD_438 609 0 100meg
R_PD_439 N86 0 100meg
R_PD_440 93 0 100meg
R_PD_441 N118 0 100meg
R_PD_442 335 0 100meg
R_PD_443 490 0 100meg
R_PD_444 N566 0 100meg
R_PD_445 N348 0 100meg
R_PD_446 N7515 0 100meg
R_PD_447 621 0 100meg
R_PD_448 N83 0 100meg
R_PD_449 508 0 100meg
R_PD_450 494 0 100meg
R_PD_451 249 0 100meg
R_PD_452 251 0 100meg
R_PD_453 32 0 100meg
R_PD_454 371 0 100meg
R_PD_455 N7704 0 100meg
R_PD_456 182 0 100meg
R_PD_457 14 0 100meg
R_PD_458 N288 0 100meg
R_PD_459 N332 0 100meg
R_PD_460 599 0 100meg
R_PD_461 446 0 100meg
R_PD_462 175 0 100meg
R_PD_463 624 0 100meg
R_PD_464 N26 0 100meg
R_PD_465 N27 0 100meg
R_PD_466 84 0 100meg
R_PD_467 274 0 100meg
R_PD_468 N7761 0 100meg
R_PD_469 486 0 100meg
R_PD_470 N251 0 100meg
R_PD_471 664 0 100meg
R_PD_472 185 0 100meg
R_PD_473 489 0 100meg
R_PD_474 422 0 100meg
R_PD_475 651 0 100meg
R_PD_476 488 0 100meg
R_PD_477 430 0 100meg
R_PD_478 681 0 100meg
R_PD_479 522 0 100meg
R_PD_480 191 0 100meg
R_PD_481 296 0 100meg
R_PD_482 680 0 100meg
R_PD_483 N597 0 100meg
R_PD_484 N25 0 100meg
R_PD_485 N631 0 100meg
R_PD_486 660 0 100meg
R_PD_487 N7737 0 100meg
R_PD_488 454 0 100meg
R_PD_489 400 0 100meg
R_PD_490 608 0 100meg
R_PD_491 N596 0 100meg
R_PD_492 176 0 100meg
R_PD_493 N7503 0 100meg
R_PD_494 N81 0 100meg
R_PD_495 N549 0 100meg
R_PD_496 N273 0 100meg
R_PD_497 N1153 0 100meg
R_PD_498 295 0 100meg
R_PD_499 N7363 0 100meg
R_PD_500 194 0 100meg
R_PD_501 633 0 100meg
R_PD_502 N534 0 100meg
R_PD_503 N88 0 100meg
R_PD_504 233 0 100meg
R_PD_505 358 0 100meg
R_PD_506 535 0 100meg
R_PD_507 411 0 100meg
R_PD_508 317 0 100meg
R_PD_509 234 0 100meg
R_PD_510 474 0 100meg
R_PD_511 148 0 100meg
R_PD_512 428 0 100meg
R_PD_513 507 0 100meg
R_PD_514 656 0 100meg
R_PD_515 N574 0 100meg
R_PD_516 390 0 100meg
R_PD_517 533 0 100meg
R_PD_518 N8124 0 100meg
R_PD_519 N7757 0 100meg
R_PD_520 431 0 100meg
R_PD_521 60 0 100meg
R_PD_522 266 0 100meg
R_PD_523 N6716 0 100meg
R_PD_524 N34 0 100meg
R_PD_525 55 0 100meg
R_PD_526 553 0 100meg
R_PD_527 642 0 100meg
R_PD_528 39 0 100meg
R_PD_529 18 0 100meg
R_PD_530 179 0 100meg
R_PD_531 126 0 100meg
R_PD_532 N245 0 100meg
R_PD_533 158 0 100meg
R_PD_534 401 0 100meg
R_PD_535 540 0 100meg
R_PD_536 462 0 100meg
R_PD_537 137 0 100meg
R_PD_538 23 0 100meg
R_PD_539 30 0 100meg
R_PD_540 221 0 100meg
R_PD_541 167 0 100meg
R_PD_542 N31 0 100meg
R_PD_543 N580 0 100meg
R_PD_544 647 0 100meg
R_PD_545 650 0 100meg
R_PD_546 132 0 100meg
R_PD_547 N87 0 100meg
R_PD_548 29 0 100meg
R_PD_549 351 0 100meg
R_PD_550 N1140 0 100meg
R_PD_551 90 0 100meg
R_PD_552 N113 0 100meg
R_PD_553 294 0 100meg
R_PD_554 N7606 0 100meg
R_PD_555 491 0 100meg
R_PD_556 N7517 0 100meg
R_PD_557 6 0 100meg
R_PD_558 N308 0 100meg
R_PD_559 216 0 100meg
R_PD_560 146 0 100meg
R_PD_561 347 0 100meg
R_PD_562 402 0 100meg
R_PD_563 N7736 0 100meg
R_PD_564 64 0 100meg
R_PD_565 641 0 100meg
R_PD_566 N7702 0 100meg
R_PD_567 526 0 100meg
R_PD_568 N8076 0 100meg
R_PD_569 73 0 100meg
R_PD_570 164 0 100meg
R_PD_571 N7476 0 100meg
R_PD_572 384 0 100meg
R_PD_573 374 0 100meg
R_PD_574 441 0 100meg
R_PD_575 432 0 100meg
R_PD_576 156 0 100meg
R_PD_577 264 0 100meg
R_PD_578 131 0 100meg
R_PD_579 449 0 100meg
R_PD_580 115 0 100meg
R_PD_581 160 0 100meg
R_PD_582 N411 0 100meg
R_PD_583 397 0 100meg
R_PD_584 450 0 100meg
R_PD_585 N7754 0 100meg
R_PD_586 186 0 100meg
R_PD_587 N386 0 100meg
R_PD_588 N7449 0 100meg
R_PD_589 497 0 100meg
R_PD_590 635 0 100meg
R_PD_591 147 0 100meg
R_PD_592 74 0 100meg
R_PD_593 421 0 100meg
R_PD_594 46 0 100meg
R_PD_595 N272 0 100meg
R_PD_596 247 0 100meg
R_PD_597 403 0 100meg
R_PD_598 198 0 100meg
R_PD_599 N7735 0 100meg
R_PD_600 N6648 0 100meg
R_PD_601 N331 0 100meg
R_PD_602 170 0 100meg
R_PD_603 N545 0 100meg
R_PD_604 173 0 100meg
R_PD_605 N7602 0 100meg
R_PD_606 N131 0 100meg
R_PD_607 N7605 0 100meg
R_PD_608 288 0 100meg
R_PD_609 674 0 100meg
R_PD_610 124 0 100meg
R_PD_611 240 0 100meg
R_PD_612 552 0 100meg
R_PD_613 8 0 100meg
R_PD_614 N145 0 100meg
R_PD_615 N7741 0 100meg
R_PD_616 227 0 100meg
R_PD_617 265 0 100meg
R_PD_618 99 0 100meg
R_PD_619 N599 0 100meg
R_PD_620 199 0 100meg
R_PD_621 515 0 100meg
R_PD_622 532 0 100meg
R_PD_623 N6925 0 100meg
R_PD_624 511 0 100meg
R_PD_625 54 0 100meg
R_PD_626 108 0 100meg
R_PD_627 217 0 100meg
R_PD_628 555 0 100meg
R_PD_629 575 0 100meg
R_PD_630 N91 0 100meg
R_PD_631 112 0 100meg
R_PD_632 578 0 100meg
R_PD_633 283 0 100meg
R_PD_634 86 0 100meg
R_PD_635 604 0 100meg
R_PD_636 N121 0 100meg
R_PD_637 N4272 0 100meg
R_PD_638 677 0 100meg
R_PD_639 28 0 100meg
R_PD_640 120 0 100meg
R_PD_641 226 0 100meg
R_PD_642 N7604 0 100meg
R_PD_643 N556 0 100meg
R_PD_644 118 0 100meg
R_PD_645 N7698 0 100meg
R_PD_646 212 0 100meg
R_PD_647 338 0 100meg
R_PD_648 303 0 100meg
R_PD_649 620 0 100meg
R_PD_650 33 0 100meg
R_PD_651 458 0 100meg
R_PD_652 98 0 100meg
R_PD_653 391 0 100meg
R_PD_654 297 0 100meg
R_PD_655 N607 0 100meg
R_PD_656 654 0 100meg
R_PD_657 392 0 100meg
R_PD_658 583 0 100meg
R_PD_659 94 0 100meg
R_PD_660 171 0 100meg
R_PD_661 571 0 100meg
R_PD_662 679 0 100meg
R_PD_663 155 0 100meg
R_PD_664 N218 0 100meg
R_PD_665 348 0 100meg
R_PD_666 379 0 100meg
R_PD_667 618 0 100meg
R_PD_668 273 0 100meg
R_PD_669 N149 0 100meg
R_PD_670 189 0 100meg
R_PD_671 376 0 100meg
R_PD_672 434 0 100meg
R_PD_673 139 0 100meg
R_PD_674 661 0 100meg
R_PD_675 80 0 100meg
R_PD_676 286 0 100meg
R_PD_677 292 0 100meg
R_PD_678 N7760 0 100meg
R_PD_679 606 0 100meg
R_PD_680 45 0 100meg
R_PD_681 637 0 100meg
R_PD_682 669 0 100meg
R_PD_683 N280 0 100meg
R_PD_684 N4739 0 100meg
R_PD_685 N73 0 100meg
R_PD_686 N616 0 100meg
R_PD_687 248 0 100meg
R_PD_688 213 0 100meg
R_PD_689 541 0 100meg
R_PD_690 478 0 100meg
R_PD_691 49 0 100meg
R_PD_692 62 0 100meg
R_PD_693 122 0 100meg
R_PD_694 N127 0 100meg
R_PD_695 506 0 100meg
R_PD_696 631 0 100meg
R_PD_697 605 0 100meg
R_PD_698 205 0 100meg
R_PD_699 N170 0 100meg
R_PD_700 N203 0 100meg
R_PD_701 220 0 100meg
R_PD_702 N4740 0 100meg
R_PD_703 N490 0 100meg
R_PD_704 N603 0 100meg
R_PD_705 469 0 100meg
R_PD_706 630 0 100meg
R_PD_707 N7504 0 100meg
R_PD_708 319 0 100meg
R_PD_709 410 0 100meg
R_PD_710 203 0 100meg
R_PD_711 143 0 100meg
R_PD_712 67 0 100meg
R_PD_713 278 0 100meg
R_PD_714 312 0 100meg
R_PD_715 435 0 100meg
R_PD_716 627 0 100meg
R_PD_717 567 0 100meg
R_PD_718 272 0 100meg
R_PD_719 281 0 100meg
R_PD_720 670 0 100meg
R_PD_721 N374 0 100meg
R_PD_722 291 0 100meg
R_PD_723 328 0 100meg
R_PD_724 340 0 100meg
R_PD_725 588 0 100meg
R_PD_726 5 0 100meg
R_PD_727 482 0 100meg
R_PD_728 566 0 100meg
R_PD_729 101 0 100meg
R_PD_730 N7473 0 100meg
R_PD_731 537 0 100meg
R_PD_732 N49 0 100meg
R_PD_733 174 0 100meg
R_PD_734 N76 0 100meg
R_PD_735 487 0 100meg
R_PD_736 N1139 0 100meg
R_PD_737 N293 0 100meg
R_PD_738 N6927 0 100meg
R_PD_739 N598 0 100meg
R_PD_740 258 0 100meg
R_PD_741 N358 0 100meg
R_PD_742 69 0 100meg
R_PD_743 510 0 100meg
R_PD_744 50 0 100meg
R_PD_745 184 0 100meg
R_PD_746 110 0 100meg
R_PD_747 N8075 0 100meg
R_PD_748 619 0 100meg
R_PD_749 436 0 100meg
R_PD_750 119 0 100meg
R_PD_751 587 0 100meg
R_PD_752 181 0 100meg
R_PD_753 N7472 0 100meg
R_PD_754 24 0 100meg
R_PD_755 57 0 100meg
R_PD_756 N7466 0 100meg
R_PD_757 N103 0 100meg
R_PD_758 9 0 100meg
R_PD_759 675 0 100meg
R_PD_760 N112 0 100meg
R_PD_761 12 0 100meg
R_PD_762 377 0 100meg
R_PD_763 459 0 100meg
R_PD_764 N7759 0 100meg
R_PD_765 140 0 100meg
R_PD_766 513 0 100meg
R_PD_767 N188 0 100meg
R_PD_768 N7626 0 100meg
R_PD_769 610 0 100meg
R_PD_770 103 0 100meg
R_PD_771 451 0 100meg
R_PD_772 40 0 100meg
R_PD_773 N1144 0 100meg
R_PD_774 N126 0 100meg
R_PD_775 593 0 100meg
R_PD_776 595 0 100meg
R_PD_777 N595 0 100meg
R_PD_778 195 0 100meg
R_PD_779 629 0 100meg
R_PD_780 456 0 100meg
R_PD_781 285 0 100meg
R_PD_782 N122 0 100meg
R_PD_783 83 0 100meg
R_PD_784 N206 0 100meg
R_PD_785 643 0 100meg
R_PD_786 676 0 100meg
R_PD_787 418 0 100meg
R_PD_788 N11 0 100meg
R_PD_789 N625 0 100meg
R_PD_790 569 0 100meg
R_PD_791 N67 0 100meg
R_PD_792 210 0 100meg
R_PD_793 447 0 100meg
R_PD_794 2 0 100meg
R_PD_795 536 0 100meg
R_PD_796 N54 0 100meg
R_PD_797 N119 0 100meg
R_PD_798 308 0 100meg
R_PD_799 N43 0 100meg
R_PD_800 429 0 100meg
R_PD_801 341 0 100meg
R_PD_802 N1147 0 100meg
R_PD_803 N4738 0 100meg
R_PD_804 N7600 0 100meg
R_PD_805 N592 0 100meg
R_PD_806 453 0 100meg
R_PD_807 628 0 100meg
R_PD_808 75 0 100meg
R_PD_809 394 0 100meg
R_PD_810 N315 0 100meg
R_PD_811 N7758 0 100meg
R_PD_812 141 0 100meg
R_PD_813 518 0 100meg
R_PD_814 460 0 100meg
R_PD_815 N7706 0 100meg
R_PD_816 463 0 100meg
R_PD_817 N257 0 100meg
R_PD_818 N158 0 100meg
R_PD_819 356 0 100meg
R_PD_820 527 0 100meg
R_PD_821 82 0 100meg
R_PD_822 105 0 100meg
R_PD_823 168 0 100meg
R_PD_824 590 0 100meg
R_PD_825 496 0 100meg
R_PD_826 362 0 100meg
R_PD_827 457 0 100meg
R_PD_828 N373 0 100meg
R_PD_829 N248 0 100meg
R_PD_830 85 0 100meg
R_PD_831 481 0 100meg
R_PD_832 607 0 100meg
R_PD_833 N7601 0 100meg
R_PD_834 636 0 100meg
R_PD_835 311 0 100meg
R_PD_836 640 0 100meg
R_PD_837 79 0 100meg
R_PD_838 378 0 100meg
R_PD_839 N24 0 100meg
R_PD_840 N1138 0 100meg
R_PD_841 644 0 100meg
R_PD_842 479 0 100meg
R_PD_843 154 0 100meg
R_PD_844 N191 0 100meg
R_PD_845 N80 0 100meg
R_PD_846 204 0 100meg
R_PD_847 480 0 100meg
R_PD_848 546 0 100meg
R_PD_849 N6924 0 100meg
R_PD_850 224 0 100meg
R_PD_851 16 0 100meg
R_PD_852 663 0 100meg
R_PD_853 70 0 100meg
R_PD_854 564 0 100meg
R_PD_855 163 0 100meg
R_PD_856 193 0 100meg
R_PD_857 77 0 100meg
R_PD_858 N503 0 100meg
R_PD_859 183 0 100meg
R_PD_860 368 0 100meg
R_PD_861 35 0 100meg
R_PD_862 666 0 100meg
R_PD_863 N7521 0 100meg
R_PD_864 N7742 0 100meg
R_PD_865 653 0 100meg
R_PD_866 188 0 100meg
R_PD_867 N117 0 100meg
R_PD_868 N591 0 100meg
R_PD_869 N185 0 100meg
R_PD_870 114 0 100meg
R_PD_871 145 0 100meg
R_PD_872 N1137 0 100meg
R_PD_873 206 0 100meg
R_PD_874 218 0 100meg
R_PD_875 N52 0 100meg
R_PD_876 387 0 100meg
R_PD_877 582 0 100meg
R_PD_878 585 0 100meg
R_PD_879 657 0 100meg
R_PD_880 667 0 100meg
R_PD_881 N335 0 100meg
R_PD_882 385 0 100meg
R_PD_883 646 0 100meg
R_PD_884 N7603 0 100meg
R_PD_885 N316 0 100meg
R_PD_886 197 0 100meg
R_PD_887 N135 0 100meg
R_PD_888 N7707 0 100meg
R_PD_889 N7607 0 100meg
R_PD_890 499 0 100meg
R_PD_891 N226 0 100meg
R_PD_892 N161 0 100meg
R_PD_893 N7739 0 100meg
R_PD_894 47 0 100meg
R_PD_895 326 0 100meg
R_PD_896 N241 0 100meg
R_PD_897 505 0 100meg
R_PD_898 N8123 0 100meg
R_PD_899 N4737 0 100meg
R_PD_900 63 0 100meg
R_PD_901 81 0 100meg
R_PD_902 315 0 100meg
R_PD_903 42 0 100meg
R_PD_904 N7516 0 100meg
R_PD_905 N7519 0 100meg
R_PD_906 336 0 100meg
R_PD_907 576 0 100meg
R_PD_908 561 0 100meg
R_PD_909 333 0 100meg
R_PD_910 123 0 100meg
R_PD_911 N7432 0 100meg
R_PD_912 N5240 0 100meg
R_PD_913 602 0 100meg
R_PD_914 25 0 100meg
R_PD_915 359 0 100meg
R_PD_916 N7470 0 100meg
R_PD_917 626 0 100meg
R_PD_918 439 0 100meg
R_PD_919 N4279 0 100meg
R_PD_920 427 0 100meg
R_PD_921 305 0 100meg
R_PD_922 284 0 100meg
R_PD_923 645 0 100meg
R_PD_924 289 0 100meg
R_PD_925 542 0 100meg
R_PD_926 N7506 0 100meg
R_PD_927 334 0 100meg
R_PD_928 196 0 100meg
R_PD_929 572 0 100meg
R_PD_930 268 0 100meg
R_PD_931 270 0 100meg
R_PD_932 373 0 100meg
R_PD_933 521 0 100meg
R_PD_934 19 0 100meg
R_PD_935 250 0 100meg
R_PD_936 N70 0 100meg
R_PD_937 361 0 100meg
R_PD_938 414 0 100meg
R_PD_939 444 0 100meg
R_PD_940 448 0 100meg
R_PD_941 570 0 100meg
R_PD_942 129 0 100meg
R_PD_943 95 0 100meg
R_PD_944 329 0 100meg
R_PD_945 N7701 0 100meg
R_PD_946 352 0 100meg
R_PD_947 353 0 100meg
R_PD_948 N338 0 100meg
R_PD_949 N164 0 100meg
R_PD_950 N141 0 100meg
R_PD_951 N1972 0 100meg
R_PD_952 345 0 100meg
R_PD_953 320 0 100meg
R_PD_954 91 0 100meg
R_PD_955 380 0 100meg
R_PD_956 282 0 100meg
R_PD_957 412 0 100meg
R_PD_958 423 0 100meg
R_PD_959 388 0 100meg
R_PD_960 N562 0 100meg
R_PD_961 11 0 100meg
R_PD_962 133 0 100meg
R_PD_963 N7465 0 100meg
R_PD_964 N559 0 100meg
R_PD_965 493 0 100meg

* Transient Simulation Directive
.TRAN 100p 10n
