* Nangila SPICE Auto-Synthesized Netlist
.SUBCKT INV_X1 A Z
M1 Z A 0 0 NMOS W=0.2u L=0.05u
M2 Z A 1 1 PMOS W=0.4u L=0.05u
.ENDS

.SUBCKT NAND2_X1 A1 A2 Z
M1 Z A1 1 1 PMOS W=0.4u L=0.05u
M2 Z A2 1 1 PMOS W=0.4u L=0.05u
M3 Z A1 int 0 NMOS W=0.2u L=0.05u
M4 int A2 0 0 NMOS W=0.2u L=0.05u
.ENDS

.SUBCKT AND2_X1 A1 A2 Z
X1 A1 A2 Z_bar NAND2_X1
X2 Z_bar Z INV_X1
.ENDS

.SUBCKT NOR2_X1 A1 A2 Z
M1 int1 A1 1 1 PMOS W=0.4u L=0.05u
M2 Z A2 int1 1 PMOS W=0.4u L=0.05u
M3 Z A1 0 0 NMOS W=0.2u L=0.05u
M4 Z A2 0 0 NMOS W=0.2u L=0.05u
.ENDS

.SUBCKT OR2_X1 A1 A2 Z
X1 A1 A2 Z_bar NOR2_X1
X2 Z_bar Z INV_X1
.ENDS

.SUBCKT XOR2_X1 A1 A2 Z
X1 A1 A2 int1 AND2_X1
X2 A1 A2 int2 NOR2_X1
X3 int1 int2 int3 NOR2_X1
X4 int3 Z INV_X1
.ENDS

.SUBCKT XNOR2_X1 A B Z
X1 A B Z_int XOR2_X1
X2 Z_int Z INV_X1
.ENDS

.SUBCKT BUF_X1 A Z
X1 A Z_bar INV_X1
X2 Z_bar Z INV_X1
.ENDS

.SUBCKT OAI21_X1 A B C Z
X1 A B C Z_bar AOI21_X1
X2 Z_bar Z INV_X1
.ENDS

.SUBCKT AOI21_X1 A B C Z
M1 Z A int1 1 PMOS W=0.4u L=0.05u
M2 int1 B 1 1 PMOS W=0.4u L=0.05u
M3 Z C 1 1 PMOS W=0.4u L=0.05u
M4 Z A 0 0 NMOS W=0.2u L=0.05u
M5 Z B 0 0 NMOS W=0.2u L=0.05u
M6 Z C 0 0 NMOS W=0.2u L=0.05u
.ENDS

.SUBCKT NAND3_X1 A1 A2 A3 Z
X1 A1 A2 int1 AND2_X1
X2 int1 A3 Z NAND2_X1
.ENDS

.SUBCKT AND3_X1 A1 A2 A3 Z
X1 A1 A2 A3 Z_bar NAND3_X1
X2 Z_bar Z INV_X1
.ENDS

.SUBCKT NOR3_X1 A1 A2 A3 Z
X1 A1 A2 int1 OR2_X1
X2 int1 A3 Z NOR2_X1
.ENDS

.SUBCKT OR3_X1 A1 A2 A3 Z
X1 A1 A2 A3 Z_bar NOR3_X1
X2 Z_bar Z INV_X1
.ENDS

.SUBCKT NAND4_X1 A1 A2 A3 A4 Z
X1 A1 A2 A3 int1 AND3_X1
X2 int1 A4 Z NAND2_X1
.ENDS

.SUBCKT AND4_X1 A1 A2 A3 A4 Z
X1 A1 A2 A3 A4 Z_bar NAND4_X1
X2 Z_bar Z INV_X1
.ENDS

.SUBCKT NOR4_X1 A1 A2 A3 A4 Z
X1 A1 A2 A3 int1 OR3_X1
X2 int1 A4 Z NOR2_X1
.ENDS

.SUBCKT OR4_X1 A1 A2 A3 A4 Z
X1 A1 A2 A3 A4 Z_bar NOR4_X1
X2 Z_bar Z INV_X1
.ENDS

.SUBCKT AOI22_X1 A B C D Z
X1 A B int1 AND2_X1
X2 C D int2 AND2_X1
X3 int1 int2 Z NOR2_X1
.ENDS

.SUBCKT OAI22_X1 A B C D Z
X1 A B int1 OR2_X1
X2 C D int2 OR2_X1
X3 int1 int2 Z NAND2_X1
.ENDS

.SUBCKT AOI211_X1 A B C D Z
X1 A B int1 AND2_X1
X2 int1 C D Z NOR3_X1
.ENDS

.SUBCKT OAI211_X1 A B C D Z
X1 A B int1 OR2_X1
X2 int1 C D Z NAND3_X1
.ENDS

.SUBCKT OAI33_X1 A B C D E F Z
X1 A B C int1 OR3_X1
X2 D E F int2 OR3_X1
X3 int1 int2 Z NAND2_X1
.ENDS

.SUBCKT AOI33_X1 A B C D E F Z
X1 A B C int1 AND3_X1
X2 D E F int2 AND3_X1
X3 int1 int2 Z NOR2_X1
.ENDS

.SUBCKT MUX2_X1 A B S Z
X1 S S_bar INV_X1
X2 A S_bar int1 AND2_X1
X3 B S int2 AND2_X1
X4 int1 int2 Z OR2_X1
.ENDS

.SUBCKT DFF_X1 D C Q QN
X1 D Q_int INV_X1
X2 Q_int Q INV_X1
X3 Q_int QN INV_X1
.ENDS

.SUBCKT DFFR_X1 D C RN Q QN
X1 D Q_int INV_X1
X2 Q_int Q INV_X1
X3 Q_int QN INV_X1
.ENDS

.SUBCKT DFFS_X1 C D Q QN SN
X1 D Q_int INV_X1
X2 Q_int Q INV_X1
X3 Q_int QN INV_X1
.ENDS

.SUBCKT DFFRS_X1 C D Q QN RN SN
X1 D Q_int INV_X1
X2 Q_int Q INV_X1
X3 Q_int QN INV_X1
.ENDS

* Provide VDD power source explicitly
Vvdd 1 0 1.8

* Auto-extracted Inputs:
V_CK CK 0 1.8
V_D D 0 0.0
V_CK CK 0 1.8
V_P_0 P_0 0 0.0
V_C_16 C_16 0 1.8
V_C_15 C_15 0 0.0
V_C_14 C_14 0 1.8
V_C_13 C_13 0 0.0
V_C_12 C_12 0 1.8
V_C_11 C_11 0 0.0
V_C_10 C_10 0 1.8
V_C_9 C_9 0 0.0
V_C_8 C_8 0 1.8
V_C_7 C_7 0 0.0
V_C_6 C_6 0 1.8
V_C_5 C_5 0 0.0
V_C_4 C_4 0 1.8
V_C_3 C_3 0 0.0
V_C_2 C_2 0 1.8
V_C_1 C_1 0 0.0
V_C_0 C_0 0 1.8

* Yosys Generated Netlist:
* SPICE netlist generated by Yosys 0.62 (git sha1 7326bb7d6641500ecb285c291a54a662cb1e76cf, clang++ 17.0.0 -fPIC -O3)

.SUBCKT dff CK Q D
X0 CK D Q 1 DFF_X1
.ENDS dff

X0 X_7 1 INV_X1
X1 X_9 2 INV_X1
X2 P_0 3 INV_X1
X3 C_5 4 INV_X1
X4 C_2 5 INV_X1
X5 C_11 6 INV_X1
X6 X_1 P_0 7 NAND2_X1
X7 X_2 X_1 P_0 8 NAND3_X1
X8 X_3 X_2 X_1 P_0 9 AND4_X1
X9 X_3 8 I13 XNOR2_X1
X10 X_1 P_0 I15 XOR2_X1
X11 X_4 9 10 NAND2_X1
X12 X_5 X_4 9 11 NAND3_X1
X13 X_6 X_5 X_4 9 12 NAND4_X1
X14 1 12 13 NOR2_X1
X15 X_7 12 I111 XNOR2_X1
X16 X_5 10 I113 XNOR2_X1
X17 X_8 13 14 NAND2_X1
X18 X_9 X_8 13 15 NAND3_X1
X19 X_10 X_9 X_8 13 16 AND4_X1
X20 X_11 16 17 NAND2_X1
X21 X_11 16 I209 XOR2_X1
X22 X_9 14 I211 XNOR2_X1
X23 X_11 X_12 16 18 NAND3_X1
X24 X_11 X_13 X_12 16 19 AND4_X1
X25 X_13 18 I309 XNOR2_X1
X26 X_3 X_2 X_1 X_4 20 NOR4_X1
X27 X_7 X_6 21 NOR2_X1
X28 X_7 X_6 X_5 X_8 22 NOR4_X1
X29 X_7 X_6 X_5 X_8 23 OR4_X1
X30 X_15 C_15 24 NAND2_X1
X31 X_14 C_14 25 NAND2_X1
X32 X_11 X_10 X_9 X_12 26 NOR4_X1
X33 26 27 INV_X1
X34 X_11 C_12 X_12 28 AOI21_X1
X35 X_10 28 6 X_11 29 AOI211_X1
X36 1 X_6 30 NOR2_X1
X37 C_8 X_8 21 31 NAND3_X1
X38 X_5 C_7 30 C_6 X_6 32 AOI221_X1
X39 C_0 C_1 X_1 33 AOI21_X1
X40 C_4 X_4 34 NAND2_X1
X41 P_0 C_9 2 35 OAI21_X1
X42 X_9 29 C_10 X_10 36 AOI211_X1
X43 35 36 37 OR2_X1
X44 X_13 P_0 C_13 38 NAND3_X1
X45 X_13 3 39 OR2_X1
X46 38 39 25 40 OAI21_X1
X47 X_14 24 27 39 41 NOR4_X1
X48 41 40 26 42 AOI21_X1
X49 23 37 42 43 AOI21_X1
X50 3 31 32 4 X_5 44 AOI221_X1
X51 20 43 44 45 OAI21_X1
X52 X_2 C_3 X_3 46 AOI21_X1
X53 46 34 X_3 47 OAI21_X1
X54 X_1 3 5 X_2 48 AOI211_X1
X55 3 33 49 NOR2_X1
X56 49 48 47 50 AOI21_X1
X57 C_16 X_16 51 NAND2_X1
X58 X_15 X_14 39 51 52 NOR4_X1
X59 20 22 26 52 53 NAND4_X1
X60 45 50 53 Z NAND3_X1
X61 X_4 9 I12 XOR2_X1
X62 X_8 13 I110 XOR2_X1
X63 X_12 17 I208 XNOR2_X1
X64 X_14 19 54 NAND2_X1
X65 X_15 X_14 19 55 NAND3_X1
X66 X_16 55 I306 XNOR2_X1
X67 X_15 54 I307 XNOR2_X1
X68 X_2 7 I14 XNOR2_X1
X69 X_6 11 I112 XNOR2_X1
X70 X_10 15 I210 XNOR2_X1
X71 X_14 19 I308 XOR2_X1
X72 CK X_4 I12 dff
X73 CK X_3 I13 dff
X74 CK X_10 I210 dff
X75 CK X_9 I211 dff
X76 CK X_16 I306 dff
X77 CK X_15 I307 dff
X78 CK X_14 I308 dff
X79 CK X_13 I309 dff
X80 CK X_2 I14 dff
X81 CK X_1 I15 dff
X82 CK X_8 I110 dff
X83 CK X_7 I111 dff
X84 CK X_6 I112 dff
X85 CK X_5 I113 dff
X86 CK X_12 I208 dff
X87 CK X_11 I209 dff

************************
* end of SPICE netlist *
************************

* Anti-Floating Pull-Downs (GMIN)
R_PD_0 X_4 0 100meg
R_PD_1 I211 0 100meg
R_PD_2 Z 0 100meg
R_PD_3 38 0 100meg
R_PD_4 21 0 100meg
R_PD_5 50 0 100meg
R_PD_6 24 0 100meg
R_PD_7 X_8 0 100meg
R_PD_8 55 0 100meg
R_PD_9 9 0 100meg
R_PD_10 39 0 100meg
R_PD_11 12 0 100meg
R_PD_12 18 0 100meg
R_PD_13 C_5 0 100meg
R_PD_14 C_2 0 100meg
R_PD_15 C_8 0 100meg
R_PD_16 D 0 100meg
R_PD_17 23 0 100meg
R_PD_18 30 0 100meg
R_PD_19 I110 0 100meg
R_PD_20 40 0 100meg
R_PD_21 X_11 0 100meg
R_PD_22 51 0 100meg
R_PD_23 C_15 0 100meg
R_PD_24 I113 0 100meg
R_PD_25 29 0 100meg
R_PD_26 52 0 100meg
R_PD_27 43 0 100meg
R_PD_28 26 0 100meg
R_PD_29 6 0 100meg
R_PD_30 I210 0 100meg
R_PD_31 1 0 100meg
R_PD_32 C_7 0 100meg
R_PD_33 C_12 0 100meg
R_PD_34 I112 0 100meg
R_PD_35 2 0 100meg
R_PD_36 I209 0 100meg
R_PD_37 48 0 100meg
R_PD_38 X_2 0 100meg
R_PD_39 I111 0 100meg
R_PD_40 C_14 0 100meg
R_PD_41 10 0 100meg
R_PD_42 C_13 0 100meg
R_PD_43 I308 0 100meg
R_PD_44 I14 0 100meg
R_PD_45 X_13 0 100meg
R_PD_46 15 0 100meg
R_PD_47 46 0 100meg
R_PD_48 37 0 100meg
R_PD_49 4 0 100meg
R_PD_50 3 0 100meg
R_PD_51 20 0 100meg
R_PD_52 C_11 0 100meg
R_PD_53 7 0 100meg
R_PD_54 8 0 100meg
R_PD_55 16 0 100meg
R_PD_56 I13 0 100meg
R_PD_57 X_16 0 100meg
R_PD_58 54 0 100meg
R_PD_59 X_6 0 100meg
R_PD_60 35 0 100meg
R_PD_61 X_3 0 100meg
R_PD_62 P_0 0 100meg
R_PD_63 17 0 100meg
R_PD_64 28 0 100meg
R_PD_65 CK 0 100meg
R_PD_66 34 0 100meg
R_PD_67 I309 0 100meg
R_PD_68 X_10 0 100meg
R_PD_69 36 0 100meg
R_PD_70 X_9 0 100meg
R_PD_71 C_0 0 100meg
R_PD_72 33 0 100meg
R_PD_73 X_15 0 100meg
R_PD_74 I307 0 100meg
R_PD_75 X_7 0 100meg
R_PD_76 53 0 100meg
R_PD_77 47 0 100meg
R_PD_78 I15 0 100meg
R_PD_79 X_14 0 100meg
R_PD_80 I306 0 100meg
R_PD_81 42 0 100meg
R_PD_82 C_1 0 100meg
R_PD_83 C_10 0 100meg
R_PD_84 C_6 0 100meg
R_PD_85 22 0 100meg
R_PD_86 25 0 100meg
R_PD_87 X_12 0 100meg
R_PD_88 44 0 100meg
R_PD_89 45 0 100meg
R_PD_90 C_16 0 100meg
R_PD_91 32 0 100meg
R_PD_92 41 0 100meg
R_PD_93 14 0 100meg
R_PD_94 X_5 0 100meg
R_PD_95 I208 0 100meg
R_PD_96 49 0 100meg
R_PD_97 19 0 100meg
R_PD_98 X_1 0 100meg
R_PD_99 31 0 100meg
R_PD_100 Q 0 100meg
R_PD_101 27 0 100meg
R_PD_102 I12 0 100meg
R_PD_103 13 0 100meg
R_PD_104 C_3 0 100meg
R_PD_105 C_4 0 100meg
R_PD_106 11 0 100meg
R_PD_107 C_9 0 100meg
R_PD_108 5 0 100meg

* Transient Simulation Directive
.TRAN 100p 10n
