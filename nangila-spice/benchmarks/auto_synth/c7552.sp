* Nangila SPICE Auto-Synthesized Netlist
.SUBCKT INV_X1 A Z
M1 Z A 0 0 NMOS W=0.2u L=0.05u
M2 Z A 1 1 PMOS W=0.4u L=0.05u
.ENDS

.SUBCKT NAND2_X1 A1 A2 Z
M1 Z A1 1 1 PMOS W=0.4u L=0.05u
M2 Z A2 1 1 PMOS W=0.4u L=0.05u
M3 Z A1 int 0 NMOS W=0.2u L=0.05u
M4 int A2 0 0 NMOS W=0.2u L=0.05u
.ENDS

.SUBCKT AND2_X1 A1 A2 Z
X1 A1 A2 Z_bar NAND2_X1
X2 Z_bar Z INV_X1
.ENDS

.SUBCKT NOR2_X1 A1 A2 Z
M1 int1 A1 1 1 PMOS W=0.4u L=0.05u
M2 Z A2 int1 1 PMOS W=0.4u L=0.05u
M3 Z A1 0 0 NMOS W=0.2u L=0.05u
M4 Z A2 0 0 NMOS W=0.2u L=0.05u
.ENDS

.SUBCKT OR2_X1 A1 A2 Z
X1 A1 A2 Z_bar NOR2_X1
X2 Z_bar Z INV_X1
.ENDS

.SUBCKT XOR2_X1 A1 A2 Z
X1 A1 A2 int1 AND2_X1
X2 A1 A2 int2 NOR2_X1
X3 int1 int2 int3 NOR2_X1
X4 int3 Z INV_X1
.ENDS

.SUBCKT XNOR2_X1 A B Z
X1 A B Z_int XOR2_X1
X2 Z_int Z INV_X1
.ENDS

.SUBCKT BUF_X1 A Z
X1 A Z_bar INV_X1
X2 Z_bar Z INV_X1
.ENDS

.SUBCKT OAI21_X1 A B C Z
X1 A B C Z_bar AOI21_X1
X2 Z_bar Z INV_X1
.ENDS

.SUBCKT AOI21_X1 A B C Z
M1 Z A int1 1 PMOS W=0.4u L=0.05u
M2 int1 B 1 1 PMOS W=0.4u L=0.05u
M3 Z C 1 1 PMOS W=0.4u L=0.05u
M4 Z A 0 0 NMOS W=0.2u L=0.05u
M5 Z B 0 0 NMOS W=0.2u L=0.05u
M6 Z C 0 0 NMOS W=0.2u L=0.05u
.ENDS

.SUBCKT NAND3_X1 A1 A2 A3 Z
X1 A1 A2 int1 AND2_X1
X2 int1 A3 Z NAND2_X1
.ENDS

.SUBCKT AND3_X1 A1 A2 A3 Z
X1 A1 A2 A3 Z_bar NAND3_X1
X2 Z_bar Z INV_X1
.ENDS

.SUBCKT NOR3_X1 A1 A2 A3 Z
X1 A1 A2 int1 OR2_X1
X2 int1 A3 Z NOR2_X1
.ENDS

.SUBCKT OR3_X1 A1 A2 A3 Z
X1 A1 A2 A3 Z_bar NOR3_X1
X2 Z_bar Z INV_X1
.ENDS

.SUBCKT NAND4_X1 A1 A2 A3 A4 Z
X1 A1 A2 A3 int1 AND3_X1
X2 int1 A4 Z NAND2_X1
.ENDS

.SUBCKT AND4_X1 A1 A2 A3 A4 Z
X1 A1 A2 A3 A4 Z_bar NAND4_X1
X2 Z_bar Z INV_X1
.ENDS

.SUBCKT NOR4_X1 A1 A2 A3 A4 Z
X1 A1 A2 A3 int1 OR3_X1
X2 int1 A4 Z NOR2_X1
.ENDS

.SUBCKT OR4_X1 A1 A2 A3 A4 Z
X1 A1 A2 A3 A4 Z_bar NOR4_X1
X2 Z_bar Z INV_X1
.ENDS

.SUBCKT AOI22_X1 A B C D Z
X1 A B int1 AND2_X1
X2 C D int2 AND2_X1
X3 int1 int2 Z NOR2_X1
.ENDS

.SUBCKT OAI22_X1 A B C D Z
X1 A B int1 OR2_X1
X2 C D int2 OR2_X1
X3 int1 int2 Z NAND2_X1
.ENDS

.SUBCKT AOI211_X1 A B C D Z
X1 A B int1 AND2_X1
X2 int1 C D Z NOR3_X1
.ENDS

.SUBCKT OAI211_X1 A B C D Z
X1 A B int1 OR2_X1
X2 int1 C D Z NAND3_X1
.ENDS

.SUBCKT OAI33_X1 A B C D E F Z
X1 A B C int1 OR3_X1
X2 D E F int2 OR3_X1
X3 int1 int2 Z NAND2_X1
.ENDS

.SUBCKT AOI33_X1 A B C D E F Z
X1 A B C int1 AND3_X1
X2 D E F int2 AND3_X1
X3 int1 int2 Z NOR2_X1
.ENDS

.SUBCKT MUX2_X1 A B S Z
X1 S S_bar INV_X1
X2 A S_bar int1 AND2_X1
X3 B S int2 AND2_X1
X4 int1 int2 Z OR2_X1
.ENDS

.SUBCKT DFF_X1 D C Q QN
X1 D Q_int INV_X1
X2 Q_int Q INV_X1
X3 Q_int QN INV_X1
.ENDS

.SUBCKT DFFR_X1 D C RN Q QN
X1 D Q_int INV_X1
X2 Q_int Q INV_X1
X3 Q_int QN INV_X1
.ENDS

.SUBCKT DFFS_X1 C D Q QN SN
X1 D Q_int INV_X1
X2 Q_int Q INV_X1
X3 Q_int QN INV_X1
.ENDS

.SUBCKT DFFRS_X1 C D Q QN RN SN
X1 D Q_int INV_X1
X2 Q_int Q INV_X1
X3 Q_int QN INV_X1
.ENDS

* Provide VDD power source explicitly
Vvdd 1 0 1.8

* Auto-extracted Inputs:
V_N1 N1 0 1.8
V_N5 N5 0 0.0
V_N9 N9 0 1.8
V_N12 N12 0 0.0
V_N15 N15 0 1.8
V_N18 N18 0 0.0
V_N23 N23 0 1.8
V_N26 N26 0 0.0
V_N29 N29 0 1.8
V_N32 N32 0 0.0
V_N35 N35 0 1.8
V_N38 N38 0 0.0
V_N41 N41 0 1.8
V_N44 N44 0 0.0
V_N47 N47 0 1.8
V_N50 N50 0 0.0
V_N53 N53 0 1.8
V_N54 N54 0 0.0
V_N55 N55 0 1.8
V_N56 N56 0 0.0
V_N57 N57 0 1.8
V_N58 N58 0 0.0
V_N59 N59 0 1.8
V_N60 N60 0 0.0
V_N61 N61 0 1.8
V_N62 N62 0 0.0
V_N63 N63 0 1.8
V_N64 N64 0 0.0
V_N65 N65 0 1.8
V_N66 N66 0 0.0
V_N69 N69 0 1.8
V_N70 N70 0 0.0
V_N73 N73 0 1.8
V_N74 N74 0 0.0
V_N75 N75 0 1.8
V_N76 N76 0 0.0
V_N77 N77 0 1.8
V_N78 N78 0 0.0
V_N79 N79 0 1.8
V_N80 N80 0 0.0
V_N81 N81 0 1.8
V_N82 N82 0 0.0
V_N83 N83 0 1.8
V_N84 N84 0 0.0
V_N85 N85 0 1.8
V_N86 N86 0 0.0
V_N87 N87 0 1.8
V_N88 N88 0 0.0
V_N89 N89 0 1.8
V_N94 N94 0 0.0
V_N97 N97 0 1.8
V_N100 N100 0 0.0
V_N103 N103 0 1.8
V_N106 N106 0 0.0
V_N109 N109 0 1.8
V_N110 N110 0 0.0
V_N111 N111 0 1.8
V_N112 N112 0 0.0
V_N113 N113 0 1.8
V_N114 N114 0 0.0
V_N115 N115 0 1.8
V_N118 N118 0 0.0
V_N121 N121 0 1.8
V_N124 N124 0 0.0
V_N127 N127 0 1.8
V_N130 N130 0 0.0
V_N133 N133 0 1.8
V_N134 N134 0 0.0
V_N135 N135 0 1.8
V_N138 N138 0 0.0
V_N141 N141 0 1.8
V_N144 N144 0 0.0
V_N147 N147 0 1.8
V_N150 N150 0 0.0
V_N151 N151 0 1.8
V_N152 N152 0 0.0
V_N153 N153 0 1.8
V_N154 N154 0 0.0
V_N155 N155 0 1.8
V_N156 N156 0 0.0
V_N157 N157 0 1.8
V_N158 N158 0 0.0
V_N159 N159 0 1.8
V_N160 N160 0 0.0
V_N161 N161 0 1.8
V_N162 N162 0 0.0
V_N163 N163 0 1.8
V_N164 N164 0 0.0
V_N165 N165 0 1.8
V_N166 N166 0 0.0
V_N167 N167 0 1.8
V_N168 N168 0 0.0
V_N169 N169 0 1.8
V_N170 N170 0 0.0
V_N171 N171 0 1.8
V_N172 N172 0 0.0
V_N173 N173 0 1.8
V_N174 N174 0 0.0
V_N175 N175 0 1.8
V_N176 N176 0 0.0
V_N177 N177 0 1.8
V_N178 N178 0 0.0
V_N179 N179 0 1.8
V_N180 N180 0 0.0
V_N181 N181 0 1.8
V_N182 N182 0 0.0
V_N183 N183 0 1.8
V_N184 N184 0 0.0
V_N185 N185 0 1.8
V_N186 N186 0 0.0
V_N187 N187 0 1.8
V_N188 N188 0 0.0
V_N189 N189 0 1.8
V_N190 N190 0 0.0
V_N191 N191 0 1.8
V_N192 N192 0 0.0
V_N193 N193 0 1.8
V_N194 N194 0 0.0
V_N195 N195 0 1.8
V_N196 N196 0 0.0
V_N197 N197 0 1.8
V_N198 N198 0 0.0
V_N199 N199 0 1.8
V_N200 N200 0 0.0
V_N201 N201 0 1.8
V_N202 N202 0 0.0
V_N203 N203 0 1.8
V_N204 N204 0 0.0
V_N205 N205 0 1.8
V_N206 N206 0 0.0
V_N207 N207 0 1.8
V_N208 N208 0 0.0
V_N209 N209 0 1.8
V_N210 N210 0 0.0
V_N211 N211 0 1.8
V_N212 N212 0 0.0
V_N213 N213 0 1.8
V_N214 N214 0 0.0
V_N215 N215 0 1.8
V_N216 N216 0 0.0
V_N217 N217 0 1.8
V_N218 N218 0 0.0
V_N219 N219 0 1.8
V_N220 N220 0 0.0
V_N221 N221 0 1.8
V_N222 N222 0 0.0
V_N223 N223 0 1.8
V_N224 N224 0 0.0
V_N225 N225 0 1.8
V_N226 N226 0 0.0
V_N227 N227 0 1.8
V_N228 N228 0 0.0
V_N229 N229 0 1.8
V_N230 N230 0 0.0
V_N231 N231 0 1.8
V_N232 N232 0 0.0
V_N233 N233 0 1.8
V_N234 N234 0 0.0
V_N235 N235 0 1.8
V_N236 N236 0 0.0
V_N237 N237 0 1.8
V_N238 N238 0 0.0
V_N239 N239 0 1.8
V_N240 N240 0 0.0
V_N242 N242 0 1.8
V_N245 N245 0 0.0
V_N248 N248 0 1.8
V_N251 N251 0 0.0
V_N254 N254 0 1.8
V_N257 N257 0 0.0
V_N260 N260 0 1.8
V_N263 N263 0 0.0
V_N267 N267 0 1.8
V_N271 N271 0 0.0
V_N274 N274 0 1.8
V_N277 N277 0 0.0
V_N280 N280 0 1.8
V_N283 N283 0 0.0
V_N286 N286 0 1.8
V_N289 N289 0 0.0
V_N293 N293 0 1.8
V_N296 N296 0 0.0
V_N299 N299 0 1.8
V_N303 N303 0 0.0
V_N307 N307 0 1.8
V_N310 N310 0 0.0
V_N313 N313 0 1.8
V_N316 N316 0 0.0
V_N319 N319 0 1.8
V_N322 N322 0 0.0
V_N325 N325 0 1.8
V_N328 N328 0 0.0
V_N331 N331 0 1.8
V_N334 N334 0 0.0
V_N337 N337 0 1.8
V_N340 N340 0 0.0
V_N343 N343 0 1.8
V_N346 N346 0 0.0
V_N349 N349 0 1.8
V_N352 N352 0 0.0
V_N355 N355 0 1.8
V_N358 N358 0 0.0
V_N361 N361 0 1.8
V_N364 N364 0 0.0
V_N367 N367 0 1.8
V_N382 N382 0 0.0
V_N241_I N241_I 0 1.8

* Yosys Generated Netlist:
* SPICE netlist generated by Yosys 0.62 (git sha1 7326bb7d6641500ecb285c291a54a662cb1e76cf, clang++ 17.0.0 -fPIC -O3)

X0 N382 1 INV_X1
X1 N18 2 INV_X1
X2 N177 3 INV_X1
X3 N176 4 INV_X1
X4 N175 5 INV_X1
X5 N41 6 INV_X1
X6 N286 7 INV_X1
X7 N334 8 INV_X1
X8 N331 9 INV_X1
X9 N328 10 INV_X1
X10 N322 11 INV_X1
X11 N319 12 INV_X1
X12 N316 13 INV_X1
X13 N313 14 INV_X1
X14 N364 15 INV_X1
X15 N358 16 INV_X1
X16 N352 17 INV_X1
X17 N346 18 INV_X1
X18 N343 19 INV_X1
X19 N355 20 INV_X1
X20 N367 21 INV_X1
X21 N5 22 INV_X1
X22 N15 N1111 INV_X1
X23 N163 N1 N1781 AND2_X1
X24 N382 N263 N267 23 NAND3_X1
X25 N38 23 24 NAND2_X1
X26 N12 N9 25 AND2_X1
X27 N12 N9 26 NAND2_X1
X28 2 N213 27 OR2_X1
X29 26 27 28 NAND2_X1
X30 N260 28 29 NAND2_X1
X31 2 N214 30 OR2_X1
X32 26 30 31 NAND2_X1
X33 N257 31 32 AND2_X1
X34 N257 31 33 NOR2_X1
X35 26 N209 2 34 OAI21_X1
X36 N251 34 35 OR2_X1
X37 2 N215 36 OR2_X1
X38 26 36 37 NAND2_X1
X39 N106 37 38 NOR2_X1
X40 N106 37 39 XOR2_X1
X41 2 N216 40 OR2_X1
X42 26 40 41 NAND2_X1
X43 N254 41 42 OR2_X1
X44 N254 41 43 NAND2_X1
X45 42 43 44 AND2_X1
X46 39 44 45 NAND2_X1
X47 35 45 46 NOR2_X1
X48 42 37 N106 47 AOI21_X1
X49 38 46 47 48 NOR3_X1
X50 32 48 49 NOR2_X1
X51 33 49 50 NOR2_X1
X52 50 28 N260 51 OAI21_X1
X53 29 51 52 AND2_X1
X54 N260 28 53 XOR2_X1
X55 32 33 54 NOR2_X1
X56 N251 34 55 NAND2_X1
X57 35 55 56 AND2_X1
X58 44 56 57 AND2_X1
X59 39 57 58 NAND2_X1
X60 58 59 INV_X1
X61 2 N155 60 OR2_X1
X62 26 60 61 NAND2_X1
X63 N296 61 62 NOR2_X1
X64 N296 61 63 XOR2_X1
X65 2 N156 64 OR2_X1
X66 26 64 65 NAND2_X1
X67 N293 65 66 NOR2_X1
X68 N293 65 67 NAND2_X1
X69 N293 65 68 XOR2_X1
X70 63 68 69 NAND2_X1
X71 69 70 INV_X1
X72 26 N157 2 71 OAI21_X1
X73 N289 71 72 NAND2_X1
X74 N135 N158 N18 73 MUX2_X1
X75 7 73 74 NAND2_X1
X76 7 73 75 NOR2_X1
X77 N18 N159 76 AND2_X1
X78 76 N144 2 77 AOI21_X1
X79 N283 77 78 AND2_X1
X80 78 79 INV_X1
X81 N283 77 80 NOR2_X1
X82 N18 N160 81 AND2_X1
X83 81 N138 2 82 AOI21_X1
X84 N280 82 83 AND2_X1
X85 N280 82 84 NOR2_X1
X86 N18 N151 85 AND2_X1
X87 85 N147 2 86 AOI21_X1
X88 N277 86 87 NOR2_X1
X89 84 87 88 NOR2_X1
X90 83 88 89 NOR2_X1
X91 80 89 90 NOR2_X1
X92 78 90 91 NOR2_X1
X93 80 89 79 92 AOI21_X1
X94 75 92 74 93 AOI21_X1
X95 72 93 94 NAND2_X1
X96 94 71 N289 95 OAI21_X1
X97 N289 71 96 XOR2_X1
X98 N286 73 97 XNOR2_X1
X99 78 80 98 NOR2_X1
X100 83 84 99 NOR2_X1
X101 N277 86 100 AND2_X1
X102 87 100 101 NOR2_X1
X103 99 101 102 AND2_X1
X104 98 102 103 AND2_X1
X105 97 103 104 AND2_X1
X106 95 96 104 105 AOI21_X1
X107 105 106 INV_X1
X108 N66 N219 N18 107 MUX2_X1
X109 15 107 108 NAND2_X1
X110 15 107 109 NOR2_X1
X111 N364 107 110 XNOR2_X1
X112 N18 N220 111 AND2_X1
X113 111 N50 2 112 AOI21_X1
X114 N361 112 113 NOR2_X1
X115 N361 112 114 AND2_X1
X116 N361 112 115 NAND2_X1
X117 N32 N221 N18 116 MUX2_X1
X118 N358 116 117 XNOR2_X1
X119 117 118 INV_X1
X120 N35 N222 N18 119 MUX2_X1
X121 20 119 120 NAND2_X1
X122 118 120 121 NOR2_X1
X123 121 116 16 122 AOI21_X1
X124 20 119 123 NOR2_X1
X125 N355 119 124 XNOR2_X1
X126 117 124 125 NAND2_X1
X127 N100 N231 N18 126 MUX2_X1
X128 8 126 127 NAND2_X1
X129 8 126 128 XNOR2_X1
X130 N18 N232 129 AND2_X1
X131 2 N124 130 AND2_X1
X132 129 130 131 NOR2_X1
X133 N331 131 132 NOR2_X1
X134 9 129 130 133 NOR3_X1
X135 N127 N233 N18 134 MUX2_X1
X136 134 135 INV_X1
X137 10 134 136 XNOR2_X1
X138 N18 N234 137 AND2_X1
X139 137 N130 2 138 AOI21_X1
X140 N325 138 139 NOR2_X1
X141 N325 138 140 AND2_X1
X142 139 140 141 NOR2_X1
X143 136 139 140 142 NOR3_X1
X144 N103 N235 N18 143 MUX2_X1
X145 11 143 144 NOR2_X1
X146 144 145 INV_X1
X147 11 143 146 NAND2_X1
X148 N18 N236 147 AND2_X1
X149 2 N23 148 AND2_X1
X150 N23 N236 N18 149 MUX2_X1
X151 12 149 150 AND2_X1
X152 12 149 151 NAND2_X1
X153 N26 N237 N18 152 MUX2_X1
X154 13 152 153 NOR2_X1
X155 13 152 154 NAND2_X1
X156 N18 N238 155 AND2_X1
X157 155 N29 2 156 AOI21_X1
X158 N29 N238 N18 157 MUX2_X1
X159 N313 156 158 NOR2_X1
X160 14 157 159 NAND2_X1
X161 154 159 153 160 OAI21_X1
X162 13 152 161 XNOR2_X1
X163 N313 156 162 NAND2_X1
X164 14 157 163 XNOR2_X1
X165 161 163 164 NOR2_X1
X166 12 149 165 NOR2_X1
X167 N18 6 166 NOR2_X1
X168 2 N41 167 NAND2_X1
X169 N310 167 168 NOR2_X1
X170 160 168 169 NOR2_X1
X171 N310 161 163 167 170 NOR4_X1
X172 160 170 171 OR2_X1
X173 12 147 148 150 160 170 172 OAI33_X1
X174 146 172 144 173 OAI21_X1
X175 21 146 172 144 174 OAI211_X1
X176 2 6 N310 175 AND3_X1
X177 161 163 175 176 NOR3_X1
X178 168 175 177 NOR2_X1
X179 150 160 176 178 OR3_X1
X180 12 149 160 176 179 OAI22_X1
X181 146 151 179 180 NAND3_X1
X182 145 180 181 NAND2_X1
X183 145 174 180 182 NAND3_X1
X184 142 145 174 180 183 AND4_X1
X185 139 134 10 184 AOI21_X1
X186 184 135 N328 185 AOI21_X1
X187 183 185 186 NOR2_X1
X188 9 129 130 132 183 185 187 OAI33_X1
X189 128 187 188 NOR2_X1
X190 188 126 8 189 AOI21_X1
X191 127 128 187 190 OAI21_X1
X192 N47 N223 N18 191 MUX2_X1
X193 191 192 INV_X1
X194 N352 191 193 XNOR2_X1
X195 193 194 INV_X1
X196 N18 N224 195 AND2_X1
X197 195 N121 2 196 AOI21_X1
X198 N349 196 197 NOR2_X1
X199 N349 196 198 NAND2_X1
X200 N349 196 199 XOR2_X1
X201 N94 N225 N18 200 MUX2_X1
X202 200 201 INV_X1
X203 N346 200 202 XNOR2_X1
X204 N97 N226 N18 203 MUX2_X1
X205 19 203 204 AND2_X1
X206 19 203 205 NAND2_X1
X207 19 203 206 NOR2_X1
X208 204 206 207 NOR2_X1
X209 N18 N217 208 AND2_X1
X210 208 N118 2 209 AOI21_X1
X211 N340 209 210 NOR2_X1
X212 N340 209 211 AND2_X1
X213 210 211 212 NOR2_X1
X214 202 207 212 213 AND3_X1
X215 199 213 214 NAND2_X1
X216 194 214 215 NOR2_X1
X217 205 201 N346 216 OAI21_X1
X218 216 200 18 217 OAI21_X1
X219 202 207 210 218 NAND3_X1
X220 217 218 219 NAND2_X1
X221 198 219 197 220 OAI21_X1
X222 220 192 N352 221 AOI21_X1
X223 221 215 190 17 191 222 AOI221_X1
X224 122 125 222 223 OAI21_X1
X225 115 223 113 224 OAI21_X1
X226 108 109 224 225 OAI21_X1
X227 95 225 226 NOR2_X1
X228 105 226 227 NOR2_X1
X229 70 106 225 95 228 OAI211_X1
X230 2 N153 229 OR2_X1
X231 26 229 230 NAND2_X1
X232 N303 230 231 XOR2_X1
X233 2 N154 232 OR2_X1
X234 26 232 233 NAND2_X1
X235 N299 233 234 NOR2_X1
X236 N299 233 235 AND2_X1
X237 234 235 236 NOR2_X1
X238 231 236 237 NAND2_X1
X239 62 63 66 238 AOI21_X1
X240 62 234 66 63 239 AOI211_X1
X241 235 239 N303 230 240 AOI211_X1
X242 240 241 INV_X1
X243 235 238 242 NOR2_X1
X244 241 237 228 N303 230 243 OAI221_X1
X245 56 243 244 NAND2_X1
X246 53 54 59 245 AND3_X1
X247 52 245 246 NOR2_X1
X248 52 243 245 247 AOI21_X1
X249 N382 N267 248 NAND2_X1
X250 N382 N263 N38 249 NAND3_X1
X251 N38 N263 N382 250 AOI21_X1
X252 250 251 INV_X1
X253 249 251 248 252 MUX2_X1
X254 24 247 252 N10101 OAI21_X1
X255 N245 N271 253 OR2_X1
X256 N38 253 1 254 OAI21_X1
X257 N245 N271 255 NAND2_X1
X258 1 N38 256 NOR2_X1
X259 N382 255 257 NAND2_X1
X260 N18 N113 258 NOR2_X1
X261 258 N251 N18 259 AOI21_X1
X262 2 N168 260 OR2_X1
X263 26 260 261 NAND2_X1
X264 N18 N106 262 NAND2_X1
X265 262 N87 N18 263 OAI21_X1
X266 261 263 264 NOR2_X1
X267 26 259 265 NAND2_X1
X268 2 N166 266 OR2_X1
X269 26 266 267 NAND2_X1
X270 N18 N88 268 NOR2_X1
X271 268 N260 N18 269 AOI21_X1
X272 269 270 INV_X1
X273 267 270 271 NAND2_X1
X274 2 N167 272 OR2_X1
X275 26 272 273 NAND2_X1
X276 N18 N257 274 NAND2_X1
X277 274 N112 N18 275 OAI21_X1
X278 26 266 269 276 NAND3_X1
X279 273 275 277 XOR2_X1
X280 271 276 277 278 NAND3_X1
X281 261 263 279 AND2_X1
X282 2 N169 280 OR2_X1
X283 26 280 281 NAND2_X1
X284 N18 N254 282 NAND2_X1
X285 282 N111 N18 283 OAI21_X1
X286 281 283 284 XNOR2_X1
X287 264 279 284 285 NOR3_X1
X288 254 265 285 286 NAND3_X1
X289 N38 257 259 26 287 OAI22_X1
X290 278 286 287 288 NOR3_X1
X291 2 N173 289 OR2_X1
X292 26 289 290 NAND2_X1
X293 N18 N110 291 NOR2_X1
X294 291 N303 N18 292 AOI21_X1
X295 292 293 INV_X1
X296 290 293 294 NAND2_X1
X297 26 289 292 295 NAND3_X1
X298 2 N174 296 OR2_X1
X299 26 296 297 NAND2_X1
X300 N18 N299 298 NAND2_X1
X301 298 N109 N18 299 OAI21_X1
X302 297 299 300 NOR2_X1
X303 297 299 301 XOR2_X1
X304 294 295 301 302 NAND3_X1
X305 25 5 N18 303 AOI21_X1
X306 N18 N86 304 NOR2_X1
X307 304 N296 N18 305 AOI21_X1
X308 303 305 306 NAND2_X1
X309 25 4 N18 307 AOI21_X1
X310 N18 N63 308 NOR2_X1
X311 308 N293 N18 309 AOI21_X1
X312 307 309 310 NAND2_X1
X313 306 310 311 NAND2_X1
X314 303 305 307 309 312 OAI22_X1
X315 302 311 312 313 NOR3_X1
X316 288 313 314 NAND2_X1
X317 25 3 N18 315 AOI21_X1
X318 N18 N64 316 NOR2_X1
X319 316 N289 N18 317 AOI21_X1
X320 315 317 318 NAND2_X1
X321 315 317 319 OR2_X1
X322 N135 N178 N18 320 MUX2_X1
X323 N18 N286 321 NAND2_X1
X324 321 N85 N18 322 OAI21_X1
X325 322 323 INV_X1
X326 320 322 324 XNOR2_X1
X327 318 319 324 325 AND3_X1
X328 N144 N179 N18 326 MUX2_X1
X329 N18 N84 327 NOR2_X1
X330 327 N283 N18 328 AOI21_X1
X331 N138 N180 N18 329 MUX2_X1
X332 N18 N83 330 NOR2_X1
X333 330 N280 N18 331 AOI21_X1
X334 326 328 329 331 332 AOI22_X1
X335 326 328 333 NOR2_X1
X336 329 331 334 NOR2_X1
X337 333 334 335 NOR2_X1
X338 332 335 336 AND2_X1
X339 N147 N171 N18 337 MUX2_X1
X340 N18 N277 338 NAND2_X1
X341 338 N65 N18 339 OAI21_X1
X342 339 340 INV_X1
X343 336 337 340 341 NAND3_X1
X344 341 333 332 342 OAI21_X1
X345 325 342 343 NAND2_X1
X346 320 323 315 317 344 OAI211_X1
X347 337 339 345 XNOR2_X1
X348 N66 N189 N18 346 MUX2_X1
X349 N62 15 N18 347 MUX2_X1
X350 346 347 348 NAND2_X1
X351 N50 N190 N18 349 MUX2_X1
X352 N18 N61 350 NOR2_X1
X353 350 N361 N18 351 AOI21_X1
X354 346 347 352 NOR2_X1
X355 352 351 349 353 AOI21_X1
X356 348 353 351 349 354 OAI211_X1
X357 N32 N191 N18 355 MUX2_X1
X358 N60 16 N18 356 MUX2_X1
X359 N35 N192 N18 357 MUX2_X1
X360 N79 20 N18 358 MUX2_X1
X361 355 356 357 358 359 AOI22_X1
X362 359 360 INV_X1
X363 355 356 361 NOR2_X1
X364 357 358 362 NOR2_X1
X365 354 360 361 362 363 OR4_X1
X366 N47 N193 N18 364 MUX2_X1
X367 N80 17 N18 365 MUX2_X1
X368 N121 N194 N18 366 MUX2_X1
X369 N18 N81 367 NOR2_X1
X370 367 N349 N18 368 AOI21_X1
X371 366 368 369 AND2_X1
X372 364 365 366 368 370 OAI22_X1
X373 369 370 364 365 371 AOI211_X1
X374 N118 N187 N18 372 MUX2_X1
X375 N18 N340 373 NAND2_X1
X376 373 N77 N18 374 OAI21_X1
X377 374 375 INV_X1
X378 372 374 376 XNOR2_X1
X379 N94 N195 N18 377 MUX2_X1
X380 N59 18 N18 378 MUX2_X1
X381 377 378 379 NOR2_X1
X382 N97 N196 N18 380 MUX2_X1
X383 N78 19 N18 381 MUX2_X1
X384 377 378 382 NAND2_X1
X385 382 381 380 383 OAI21_X1
X386 379 383 381 380 384 AOI211_X1
X387 371 376 384 385 NAND3_X1
X388 N100 N200 N18 386 MUX2_X1
X389 N56 8 N18 387 MUX2_X1
X390 N124 N201 N18 388 MUX2_X1
X391 N55 9 N18 389 MUX2_X1
X392 386 387 388 389 390 AOI22_X1
X393 390 389 388 386 387 391 OAI221_X1
X394 N130 N203 N18 392 MUX2_X1
X395 N18 N53 393 NOR2_X1
X396 393 N325 N18 394 AOI21_X1
X397 392 394 395 NAND2_X1
X398 N127 N202 N18 396 MUX2_X1
X399 N18 N54 397 NOR2_X1
X400 397 N328 N18 398 AOI21_X1
X401 396 398 399 NAND2_X1
X402 395 399 400 NAND2_X1
X403 392 394 396 398 401 OAI22_X1
X404 391 400 401 402 OR3_X1
X405 402 403 INV_X1
X406 N103 N204 N18 404 MUX2_X1
X407 N73 11 N18 405 MUX2_X1
X408 404 405 406 NAND2_X1
X409 N23 N205 N18 407 MUX2_X1
X410 N75 12 N18 408 MUX2_X1
X411 404 405 409 NOR2_X1
X412 409 408 407 410 AOI21_X1
X413 406 410 408 407 411 OAI211_X1
X414 N70 166 412 NAND2_X1
X415 N26 N206 N18 413 MUX2_X1
X416 N76 13 N18 414 MUX2_X1
X417 413 414 415 NOR2_X1
X418 N29 N207 N18 416 MUX2_X1
X419 N74 14 N18 417 MUX2_X1
X420 413 414 418 NAND2_X1
X421 418 417 416 419 OAI21_X1
X422 415 419 417 416 420 AOI211_X1
X423 N70 166 420 421 NAND3_X1
X424 416 417 413 414 422 OAI211_X1
X425 418 421 422 423 AND3_X1
X426 407 408 404 405 424 OAI211_X1
X427 406 424 423 411 425 OAI211_X1
X428 400 398 396 426 OAI21_X1
X429 388 389 386 387 427 OAI211_X1
X430 427 426 391 428 OAI21_X1
X431 428 425 403 386 387 429 AOI221_X1
X432 385 429 430 OR2_X1
X433 372 375 384 431 NAND3_X1
X434 380 381 377 378 432 OAI211_X1
X435 382 431 432 433 NAND3_X1
X436 366 368 364 365 434 OAI211_X1
X437 434 435 INV_X1
X438 435 433 371 364 365 436 AOI221_X1
X439 363 430 436 437 AOI21_X1
X440 N18 N70 438 NOR2_X1
X441 411 438 6 439 AOI21_X1
X442 N89 412 420 439 440 NAND4_X1
X443 354 359 361 441 NOR3_X1
X444 349 351 346 347 442 OAI211_X1
X445 348 442 443 NAND2_X1
X446 363 385 402 440 444 NOR4_X1
X447 437 441 443 444 N10704 OR4_X1
X448 325 336 345 N10704 445 NAND4_X1
X449 318 343 344 445 446 AND4_X1
X450 281 283 261 263 447 AOI211_X1
X451 264 447 448 NOR2_X1
X452 26 259 285 449 NAND3_X1
X453 278 448 449 450 AOI21_X1
X454 276 275 273 451 OAI21_X1
X455 450 451 271 452 AOI21_X1
X456 255 256 452 254 453 AOI22_X1
X457 311 305 303 454 OAI21_X1
X458 294 300 455 NAND2_X1
X459 295 455 454 302 456 OAI211_X1
X460 453 456 288 457 AOI21_X1
X461 457 446 314 N10102 OAI21_X1
X462 128 187 N10350 XOR2_X1
X463 132 133 458 NOR2_X1
X464 186 458 N10351 XNOR2_X1
X465 140 182 459 NOR2_X1
X466 139 459 460 OR2_X1
X467 136 460 N10352 XNOR2_X1
X468 141 182 N10353 XNOR2_X1
X469 228 238 461 NAND2_X1
X470 234 236 461 462 AOI21_X1
X471 231 462 N10760 XNOR2_X1
X472 236 461 N10761 XOR2_X1
X473 66 67 227 463 AOI21_X1
X474 63 463 N10762 XNOR2_X1
X475 68 227 N10763 XOR2_X1
X476 248 250 464 XNOR2_X1
X477 N267 248 249 465 MUX2_X1
X478 247 465 466 NAND2_X1
X479 466 464 247 N10837 OAI21_X1
X480 249 251 467 NAND2_X1
X481 247 467 N10839 XNOR2_X1
X482 110 224 N10905 XNOR2_X1
X483 113 114 468 NOR2_X1
X484 223 468 N10906 XOR2_X1
X485 120 123 222 469 OAI21_X1
X486 118 469 N10907 XNOR2_X1
X487 124 222 N10908 XNOR2_X1
X488 96 99 470 XNOR2_X1
X489 97 98 471 XOR2_X1
X490 470 471 472 XNOR2_X1
X491 90 89 79 473 AOI21_X1
X492 87 473 474 XNOR2_X1
X493 93 474 475 XNOR2_X1
X494 101 475 476 NOR2_X1
X495 101 475 477 XNOR2_X1
X496 93 104 478 OR2_X1
X497 91 103 479 NOR2_X1
X498 83 84 100 480 MUX2_X1
X499 479 480 481 XOR2_X1
X500 478 481 482 XNOR2_X1
X501 476 482 101 483 AOI21_X1
X502 477 483 225 484 MUX2_X1
X503 472 484 485 XNOR2_X1
X504 63 66 486 XNOR2_X1
X505 231 236 487 XOR2_X1
X506 486 487 488 XNOR2_X1
X507 239 242 489 NOR2_X1
X508 235 489 69 490 MUX2_X1
X509 488 490 491 XNOR2_X1
X510 236 489 492 NOR2_X1
X511 63 231 493 XNOR2_X1
X512 67 493 494 XNOR2_X1
X513 492 494 495 XNOR2_X1
X514 495 491 95 496 MUX2_X1
X515 491 495 105 497 MUX2_X1
X516 496 497 225 498 MUX2_X1
X517 485 498 N11333 XNOR2_X1
X518 39 44 499 XNOR2_X1
X519 53 54 500 XOR2_X1
X520 499 500 501 XNOR2_X1
X521 464 465 52 502 MUX2_X1
X522 465 464 246 503 MUX2_X1
X523 502 503 243 504 MUX2_X1
X524 501 504 505 XNOR2_X1
X525 35 42 506 NAND2_X1
X526 43 42 35 507 MUX2_X1
X527 48 507 508 XOR2_X1
X528 50 508 509 XNOR2_X1
X529 56 509 510 XOR2_X1
X530 48 58 511 NAND2_X1
X531 33 32 511 512 MUX2_X1
X532 42 43 55 513 MUX2_X1
X533 512 513 514 XNOR2_X1
X534 56 514 515 NAND2_X1
X535 515 509 56 516 OAI21_X1
X536 510 516 243 517 MUX2_X1
X537 505 517 N11334 XNOR2_X1
X538 217 219 210 518 MUX2_X1
X539 204 210 519 NOR2_X1
X540 206 519 520 NOR2_X1
X541 518 520 521 XNOR2_X1
X542 220 521 522 XNOR2_X1
X543 214 220 523 NAND2_X1
X544 213 219 524 NOR2_X1
X545 206 204 211 525 MUX2_X1
X546 524 525 526 XNOR2_X1
X547 523 526 527 XNOR2_X1
X548 522 527 212 528 MUX2_X1
X549 212 522 529 XNOR2_X1
X550 528 529 189 530 MUX2_X1
X551 202 207 531 XNOR2_X1
X552 194 199 532 XNOR2_X1
X553 531 532 533 XNOR2_X1
X554 530 533 534 XNOR2_X1
X555 114 113 122 535 MUX2_X1
X556 468 535 536 NOR2_X1
X557 110 117 537 XOR2_X1
X558 123 537 538 XNOR2_X1
X559 536 538 539 XNOR2_X1
X560 117 120 540 XOR2_X1
X561 114 535 125 541 MUX2_X1
X562 110 468 542 XOR2_X1
X563 540 542 543 XNOR2_X1
X564 541 543 544 XNOR2_X1
X565 544 539 222 545 MUX2_X1
X566 534 545 N11340 XNOR2_X1
X567 150 165 546 NOR2_X1
X568 145 146 547 AND2_X1
X569 546 547 548 XNOR2_X1
X570 158 162 168 549 AOI21_X1
X571 169 171 168 550 AOI21_X1
X572 549 550 551 XOR2_X1
X573 172 551 552 XNOR2_X1
X574 21 168 175 553 NOR3_X1
X575 N367 177 554 NOR2_X1
X576 553 554 N10025 NOR2_X1
X577 178 179 555 AND2_X1
X578 162 549 175 556 MUX2_X1
X579 555 556 557 XNOR2_X1
X580 554 N10025 552 558 MUX2_X1
X581 558 557 553 559 AOI21_X1
X582 548 559 560 XNOR2_X1
X583 161 163 561 XOR2_X1
X584 132 133 185 562 MUX2_X1
X585 458 562 563 NOR2_X1
X586 128 136 564 XNOR2_X1
X587 140 564 565 XNOR2_X1
X588 563 565 566 XNOR2_X1
X589 139 458 567 XNOR2_X1
X590 564 567 568 XNOR2_X1
X591 562 133 142 569 MUX2_X1
X592 568 569 570 XOR2_X1
X593 21 173 570 571 NAND3_X1
X594 21 181 566 572 AOI21_X1
X595 572 570 181 573 OAI21_X1
X596 571 573 174 566 574 OAI211_X1
X597 561 574 575 XNOR2_X1
X598 560 575 N11342 XNOR2_X1
X599 N57 N5 N881 OR2_X1
X600 N242 22 N1110 NAND2_X1
X601 168 553 576 NOR2_X1
X602 171 553 164 577 AOI21_X1
X603 165 577 151 578 AOI21_X1
X604 547 578 N10109 XOR2_X1
X605 546 577 N10110 XNOR2_X1
X606 162 168 553 579 OAI21_X1
X607 159 579 580 NAND2_X1
X608 161 580 N10111 XNOR2_X1
X609 163 576 N10112 XOR2_X1
X610 101 225 N10632 XOR2_X1
X611 56 243 N10641 XOR2_X1
X612 478 225 93 581 OAI21_X1
X613 96 581 N10711 XNOR2_X1
X614 91 103 225 582 AOI21_X1
X615 97 582 N10712 XNOR2_X1
X616 89 102 225 583 AOI21_X1
X617 98 583 N10713 XNOR2_X1
X618 87 101 225 584 AOI21_X1
X619 99 584 N10714 XNOR2_X1
X620 54 59 243 585 NAND3_X1
X621 50 585 586 NAND2_X1
X622 53 586 N10715 XOR2_X1
X623 48 244 45 587 OAI21_X1
X624 54 587 N10716 XOR2_X1
X625 57 243 506 43 588 AOI22_X1
X626 39 588 N10717 XNOR2_X1
X627 35 244 589 NAND2_X1
X628 44 589 N10718 XOR2_X1
X629 190 212 N10827 XOR2_X1
X630 220 214 189 590 OAI21_X1
X631 194 590 N10868 XNOR2_X1
X632 219 213 190 591 AOI21_X1
X633 199 591 N10869 XNOR2_X1
X634 210 212 190 592 AOI21_X1
X635 205 206 592 593 OAI21_X1
X636 202 593 N10870 XOR2_X1
X637 207 592 N10871 XNOR2_X1
X638 N150 N184 N228 N240 N882 NAND4_X1
X639 N210 N152 N218 N230 N883 NAND4_X1
X640 N183 N182 N185 N186 N884 NAND4_X1
X641 N162 N172 N188 N199 N885 NAND4_X1
X642 N134 N133 22 N1113 NAND3_X1
X643 152 157 594 XNOR2_X1
X644 143 149 595 XNOR2_X1
X645 594 595 596 XNOR2_X1
X646 135 138 597 XNOR2_X1
X647 126 131 598 XOR2_X1
X648 597 598 599 XNOR2_X1
X649 N44 N239 N18 600 MUX2_X1
X650 166 N229 N18 601 AOI21_X1
X651 600 601 602 XNOR2_X1
X652 37 40 41 36 603 OAI22_X1
X653 N212 N211 604 XNOR2_X1
X654 N18 26 604 N209 605 OAI211_X1
X655 605 604 N209 606 AOI21_X1
X656 28 30 31 27 607 OAI22_X1
X657 603 607 608 XOR2_X1
X658 606 608 609 XNOR2_X1
X659 77 82 610 XOR2_X1
X660 N141 N161 N18 611 MUX2_X1
X661 230 232 233 229 612 OAI22_X1
X662 610 612 613 XNOR2_X1
X663 86 611 614 XOR2_X1
X664 613 614 615 XNOR2_X1
X665 61 64 65 60 616 OAI22_X1
X666 71 73 617 XOR2_X1
X667 616 617 618 XNOR2_X1
X668 N115 N227 N18 619 MUX2_X1
X669 209 619 620 XOR2_X1
X670 200 203 621 XOR2_X1
X671 192 196 622 XNOR2_X1
X672 620 622 623 XNOR2_X1
X673 621 623 624 XNOR2_X1
X674 116 119 625 XNOR2_X1
X675 107 112 626 XOR2_X1
X676 625 626 627 XNOR2_X1
X677 615 618 628 XNOR2_X1
X678 596 602 629 XNOR2_X1
X679 599 629 630 XNOR2_X1
X680 624 627 631 XNOR2_X1
X681 609 628 630 631 N10574 NAND4_X1
X682 414 417 632 XOR2_X1
X683 387 394 633 XNOR2_X1
X684 632 633 634 XNOR2_X1
X685 438 N310 N18 635 AOI21_X1
X686 405 635 636 XNOR2_X1
X687 N18 N69 637 NOR2_X1
X688 637 N307 N18 638 AOI21_X1
X689 408 638 639 XNOR2_X1
X690 636 639 640 XNOR2_X1
X691 389 398 641 XOR2_X1
X692 640 641 642 XNOR2_X1
X693 305 309 643 XNOR2_X1
X694 292 299 644 XNOR2_X1
X695 643 644 645 XNOR2_X1
X696 328 331 646 XOR2_X1
X697 317 322 647 XOR2_X1
X698 646 647 648 XNOR2_X1
X699 N18 N274 649 NAND2_X1
X700 649 N82 N18 650 OAI21_X1
X701 339 650 651 XNOR2_X1
X702 648 651 652 XNOR2_X1
X703 634 642 645 652 653 OAI22_X1
X704 653 642 634 654 AOI21_X1
X705 263 283 655 XOR2_X1
X706 N18 N248 656 NAND2_X1
X707 656 N114 N18 657 OAI21_X1
X708 259 657 658 XNOR2_X1
X709 655 658 659 XNOR2_X1
X710 N263 N267 660 XOR2_X1
X711 N18 N245 N271 661 AOI21_X1
X712 N18 660 661 253 662 AOI22_X1
X713 269 275 663 XNOR2_X1
X714 662 663 664 XNOR2_X1
X715 659 664 665 XNOR2_X1
X716 351 358 666 XNOR2_X1
X717 347 356 667 XNOR2_X1
X718 666 667 668 XNOR2_X1
X719 368 378 669 XNOR2_X1
X720 365 381 670 XNOR2_X1
X721 669 670 671 XNOR2_X1
X722 N18 N337 672 NAND2_X1
X723 672 N58 N18 673 OAI21_X1
X724 374 673 674 XNOR2_X1
X725 671 674 675 XNOR2_X1
X726 665 668 675 676 OAI21_X1
X727 676 675 668 645 652 677 AOI221_X1
X728 654 677 N10575 NAND2_X1
X729 404 407 678 XNOR2_X1
X730 413 416 679 XOR2_X1
X731 N44 N208 N18 680 MUX2_X1
X732 166 N198 N18 681 AOI21_X1
X733 680 681 682 XOR2_X1
X734 679 682 683 XNOR2_X1
X735 678 683 684 XNOR2_X1
X736 388 396 685 XNOR2_X1
X737 386 392 686 XNOR2_X1
X738 685 686 687 XNOR2_X1
X739 N115 N197 N18 688 MUX2_X1
X740 372 688 689 XNOR2_X1
X741 364 366 690 XNOR2_X1
X742 689 690 691 XNOR2_X1
X743 349 357 692 XOR2_X1
X744 346 355 693 XNOR2_X1
X745 692 693 694 XNOR2_X1
X746 377 380 695 XNOR2_X1
X747 N18 5 307 696 NAND3_X1
X748 N18 4 303 697 NAND3_X1
X749 696 697 698 NAND2_X1
X750 326 329 699 XOR2_X1
X751 698 699 700 XNOR2_X1
X752 315 320 701 XNOR2_X1
X753 N141 N181 N18 702 MUX2_X1
X754 290 296 297 289 703 OAI22_X1
X755 701 703 704 XNOR2_X1
X756 337 702 705 XNOR2_X1
X757 704 705 706 XNOR2_X1
X758 700 706 707 XNOR2_X1
X759 261 280 281 260 708 OAI22_X1
X760 N165 N164 709 XNOR2_X1
X761 N18 26 709 N170 710 OAI211_X1
X762 710 709 N170 711 AOI21_X1
X763 267 272 273 266 712 OAI22_X1
X764 708 712 713 XOR2_X1
X765 711 713 714 XNOR2_X1
X766 691 695 715 XNOR2_X1
X767 694 715 716 XNOR2_X1
X768 684 687 717 XNOR2_X1
X769 707 714 716 717 N10576 NAND4_X1
X770 N882 N883 N884 N885 718 OR4_X1
X771 N10574 N10575 N10576 718 N10729 OR4_X1
X772 24 247 252 N10104 OAI21_X1
X773 457 446 314 N10628 OAI21_X1
X774 24 247 252 N10706 OAI21_X1
X775 24 247 252 N10759 OAI21_X1
V0 N18 N676 DC 0
V1 N286 N509 DC 0
V2 N283 N507 DC 0
V3 N1111 N582 DC 0
V4 N18 N682 DC 0
V5 N280 N505 DC 0
V6 N322 N545 DC 0
V7 N1 N590 DC 0
V8 N319 N543 DC 0
V9 N274 N501 DC 0
V10 N18 N689 DC 0
V11 N316 N541 DC 0
V12 N313 N539 DC 0
V13 N310 N537 DC 0
V14 N277 N707 DC 0
V15 N18 N2390 DC 0
V16 N307 N535 DC 0
V17 N267 N492 DC 0
V18 N263 N489 DC 0
V19 N260 N486 DC 0
V20 N18 N2384 DC 0
V21 N257 N484 DC 0
V22 N254 N482 DC 0
V23 N367 N750 DC 0
V24 N248 N478 DC 0
V25 N1111 N1114 DC 0
V26 N18 N2368 DC 0
V27 N340 N813 DC 0
V28 N38 N1431 DC 0
V29 N38 N1428 DC 0
V30 N325 N547 DC 0
V31 Vdd N2347 DC 0
V32 N328 N549 DC 0
V33 N331 N551 DC 0
V34 N334 N553 DC 0
V35 N10839 N10781 DC 0
V36 N337 N556 DC 0
V37 N18 N1125 DC 0
V38 N10837 N10778 DC 0
V39 N1110 N1112 DC 0
V40 N18 N2331 DC 0
V41 N38 N614 DC 0
V42 N18 N2315 DC 0
V43 N18 N2309 DC 0
V44 N18 N2293 DC 0
V45 N18 N2287 DC 0
V46 N303 N519 DC 0
V47 N1 N1490 DC 0
V48 N1113 N1489 DC 0
V49 N106 N2275 DC 0
V50 N241_I N241_O DC 0
V51 N106 N2267 DC 0
V52 N367 N871 DC 0
V53 N10102 N10103 DC 0
V54 N18 N2412 DC 0
V55 N18 N2406 DC 0
V56 N38 N1311 DC 0
V57 N38 N1308 DC 0
V58 N38 N1299 DC 0
V59 N343 N559 DC 0
V60 Vdd N2240 DC 0
V61 N299 N517 DC 0
V62 N1 N889 DC 0
V63 N15 N625 DC 0
V64 N346 N561 DC 0
V65 N349 N563 DC 0
V66 N352 N565 DC 0
V67 N38 N1287 DC 0
V68 N1 N1116 DC 0
V69 N355 N567 DC 0
V70 N18 N1277 DC 0
V71 N296 N515 DC 0
V72 N38 N636 DC 0
V73 N18 N1270 DC 0
V74 N1 N388 DC 0
V75 N251 N643 DC 0
V76 N260 N1828 DC 0
V77 N257 N1829 DC 0
V78 N1 N387 DC 0
V79 N254 N1830 DC 0
V80 N251 N1833 DC 0
V81 N260 N1840 DC 0
V82 N257 N1841 DC 0
V83 N254 N1842 DC 0
V84 N106 N945 DC 0
V85 N358 N569 DC 0
V86 N293 N513 DC 0
V87 N361 N571 DC 0
V88 N106 N657 DC 0
V89 N251 N1843 DC 0
V90 N18 N1256 DC 0
V91 N10837 N10838 DC 0
V92 N10839 N10840 DC 0
V93 N303 N1867 DC 0
V94 N299 N1868 DC 0
V95 N296 N1869 DC 0
V96 N289 N1870 DC 0
V97 N286 N1871 DC 0
V98 N283 N1872 DC 0
V99 N280 N1873 DC 0
V100 N293 N1874 DC 0
V101 N277 N1875 DC 0
V102 N303 N1876 DC 0
V103 N299 N1877 DC 0
V104 N296 N1878 DC 0
V105 N293 N1879 DC 0
V106 N289 N1880 DC 0
V107 N286 N1881 DC 0
V108 N283 N1882 DC 0
V109 N280 N1883 DC 0
V110 N277 N1884 DC 0
V111 N18 N1913 DC 0
V112 N334 N1931 DC 0
V113 N331 N1932 DC 0
V114 N328 N1933 DC 0
V115 N325 N1934 DC 0
V116 N322 N1935 DC 0
V117 N364 N573 DC 0
V118 N319 N1936 DC 0
V119 N316 N1937 DC 0
V120 N313 N1938 DC 0
V121 N334 N1939 DC 0
V122 N289 N511 DC 0
V123 N331 N1940 DC 0
V124 N328 N1941 DC 0
V125 N322 N1942 DC 0
V126 N319 N1943 DC 0
V127 N316 N1944 DC 0
V128 N313 N1945 DC 0
V129 N325 N1946 DC 0
V130 N18 N1136 DC 0
V131 N18 N1147 DC 0
V132 N364 N1968 DC 0
V133 N361 N1969 DC 0
V134 N358 N1970 DC 0
V135 N355 N1971 DC 0
V136 N352 N1972 DC 0
V137 N349 N1973 DC 0
V138 N346 N1974 DC 0
V139 N343 N1975 DC 0
V140 N340 N1976 DC 0
V141 N18 N1160 DC 0
V142 N18 N1175 DC 0
V143 N18 N1182 DC 0
V144 N18 N1997 DC 0
V145 N364 N2015 DC 0
V146 N361 N2016 DC 0
V147 N358 N2017 DC 0
V148 N352 N2018 DC 0
V149 N349 N2019 DC 0
V150 N346 N2020 DC 0
V151 N343 N2021 DC 0
V152 N355 N2022 DC 0
V153 N340 N2023 DC 0
V154 N18 N1233 DC 0
V155 N18 N1249 DC 0
V156 N18 N1244 DC 0

************************
* end of SPICE netlist *
************************

* Anti-Floating Pull-Downs (GMIN)
R_PD_0 96 0 100meg
R_PD_1 177 0 100meg
R_PD_2 187 0 100meg
R_PD_3 N144 0 100meg
R_PD_4 413 0 100meg
R_PD_5 157 0 100meg
R_PD_6 443 0 100meg
R_PD_7 559 0 100meg
R_PD_8 275 0 100meg
R_PD_9 117 0 100meg
R_PD_10 N10109 0 100meg
R_PD_11 38 0 100meg
R_PD_12 468 0 100meg
R_PD_13 573 0 100meg
R_PD_14 N10907 0 100meg
R_PD_15 472 0 100meg
R_PD_16 398 0 100meg
R_PD_17 225 0 100meg
R_PD_18 259 0 100meg
R_PD_19 N10632 0 100meg
R_PD_20 330 0 100meg
R_PD_21 109 0 100meg
R_PD_22 471 0 100meg
R_PD_23 363 0 100meg
R_PD_24 N200 0 100meg
R_PD_25 596 0 100meg
R_PD_26 72 0 100meg
R_PD_27 617 0 100meg
R_PD_28 313 0 100meg
R_PD_29 652 0 100meg
R_PD_30 512 0 100meg
R_PD_31 161 0 100meg
R_PD_32 704 0 100meg
R_PD_33 304 0 100meg
R_PD_34 76 0 100meg
R_PD_35 N189 0 100meg
R_PD_36 694 0 100meg
R_PD_37 600 0 100meg
R_PD_38 501 0 100meg
R_PD_39 N883 0 100meg
R_PD_40 N334 0 100meg
R_PD_41 211 0 100meg
R_PD_42 200 0 100meg
R_PD_43 229 0 100meg
R_PD_44 502 0 100meg
R_PD_45 239 0 100meg
R_PD_46 485 0 100meg
R_PD_47 594 0 100meg
R_PD_48 560 0 100meg
R_PD_49 N234 0 100meg
R_PD_50 383 0 100meg
R_PD_51 690 0 100meg
R_PD_52 354 0 100meg
R_PD_53 N172 0 100meg
R_PD_54 102 0 100meg
R_PD_55 N9 0 100meg
R_PD_56 52 0 100meg
R_PD_57 127 0 100meg
R_PD_58 321 0 100meg
R_PD_59 43 0 100meg
R_PD_60 557 0 100meg
R_PD_61 N10111 0 100meg
R_PD_62 242 0 100meg
R_PD_63 135 0 100meg
R_PD_64 N35 0 100meg
R_PD_65 709 0 100meg
R_PD_66 N29 0 100meg
R_PD_67 222 0 100meg
R_PD_68 563 0 100meg
R_PD_69 N239 0 100meg
R_PD_70 61 0 100meg
R_PD_71 625 0 100meg
R_PD_72 324 0 100meg
R_PD_73 215 0 100meg
R_PD_74 648 0 100meg
R_PD_75 703 0 100meg
R_PD_76 N299 0 100meg
R_PD_77 612 0 100meg
R_PD_78 464 0 100meg
R_PD_79 702 0 100meg
R_PD_80 48 0 100meg
R_PD_81 228 0 100meg
R_PD_82 529 0 100meg
R_PD_83 713 0 100meg
R_PD_84 N361 0 100meg
R_PD_85 350 0 100meg
R_PD_86 106 0 100meg
R_PD_87 58 0 100meg
R_PD_88 230 0 100meg
R_PD_89 260 0 100meg
R_PD_90 10 0 100meg
R_PD_91 551 0 100meg
R_PD_92 437 0 100meg
R_PD_93 N209 0 100meg
R_PD_94 N100 0 100meg
R_PD_95 N210 0 100meg
R_PD_96 545 0 100meg
R_PD_97 56 0 100meg
R_PD_98 68 0 100meg
R_PD_99 528 0 100meg
R_PD_100 208 0 100meg
R_PD_101 424 0 100meg
R_PD_102 589 0 100meg
R_PD_103 37 0 100meg
R_PD_104 134 0 100meg
R_PD_105 406 0 100meg
R_PD_106 N254 0 100meg
R_PD_107 3 0 100meg
R_PD_108 523 0 100meg
R_PD_109 N884 0 100meg
R_PD_110 20 0 100meg
R_PD_111 276 0 100meg
R_PD_112 622 0 100meg
R_PD_113 404 0 100meg
R_PD_114 549 0 100meg
R_PD_115 565 0 100meg
R_PD_116 307 0 100meg
R_PD_117 396 0 100meg
R_PD_118 416 0 100meg
R_PD_119 539 0 100meg
R_PD_120 530 0 100meg
R_PD_121 355 0 100meg
R_PD_122 N10641 0 100meg
R_PD_123 N110 0 100meg
R_PD_124 N167 0 100meg
R_PD_125 214 0 100meg
R_PD_126 N60 0 100meg
R_PD_127 N10871 0 100meg
R_PD_128 N10763 0 100meg
R_PD_129 671 0 100meg
R_PD_130 N194 0 100meg
R_PD_131 684 0 100meg
R_PD_132 N82 0 100meg
R_PD_133 165 0 100meg
R_PD_134 271 0 100meg
R_PD_135 504 0 100meg
R_PD_136 180 0 100meg
R_PD_137 689 0 100meg
R_PD_138 556 0 100meg
R_PD_139 142 0 100meg
R_PD_140 151 0 100meg
R_PD_141 364 0 100meg
R_PD_142 483 0 100meg
R_PD_143 708 0 100meg
R_PD_144 302 0 100meg
R_PD_145 N79 0 100meg
R_PD_146 17 0 100meg
R_PD_147 N97 0 100meg
R_PD_148 503 0 100meg
R_PD_149 519 0 100meg
R_PD_150 N133 0 100meg
R_PD_151 166 0 100meg
R_PD_152 36 0 100meg
R_PD_153 343 0 100meg
R_PD_154 N77 0 100meg
R_PD_155 138 0 100meg
R_PD_156 202 0 100meg
R_PD_157 N23 0 100meg
R_PD_158 N221 0 100meg
R_PD_159 N89 0 100meg
R_PD_160 638 0 100meg
R_PD_161 467 0 100meg
R_PD_162 476 0 100meg
R_PD_163 322 0 100meg
R_PD_164 N147 0 100meg
R_PD_165 257 0 100meg
R_PD_166 261 0 100meg
R_PD_167 N153 0 100meg
R_PD_168 236 0 100meg
R_PD_169 325 0 100meg
R_PD_170 N10351 0 100meg
R_PD_171 658 0 100meg
R_PD_172 53 0 100meg
R_PD_173 59 0 100meg
R_PD_174 514 0 100meg
R_PD_175 613 0 100meg
R_PD_176 113 0 100meg
R_PD_177 N217 0 100meg
R_PD_178 N106 0 100meg
R_PD_179 310 0 100meg
R_PD_180 128 0 100meg
R_PD_181 369 0 100meg
R_PD_182 287 0 100meg
R_PD_183 318 0 100meg
R_PD_184 N94 0 100meg
R_PD_185 548 0 100meg
R_PD_186 N134 0 100meg
R_PD_187 N346 0 100meg
R_PD_188 125 0 100meg
R_PD_189 N84 0 100meg
R_PD_190 365 0 100meg
R_PD_191 616 0 100meg
R_PD_192 712 0 100meg
R_PD_193 516 0 100meg
R_PD_194 N114 0 100meg
R_PD_195 255 0 100meg
R_PD_196 92 0 100meg
R_PD_197 409 0 100meg
R_PD_198 22 0 100meg
R_PD_199 475 0 100meg
R_PD_200 550 0 100meg
R_PD_201 509 0 100meg
R_PD_202 N74 0 100meg
R_PD_203 44 0 100meg
R_PD_204 71 0 100meg
R_PD_205 558 0 100meg
R_PD_206 256 0 100meg
R_PD_207 262 0 100meg
R_PD_208 N193 0 100meg
R_PD_209 632 0 100meg
R_PD_210 41 0 100meg
R_PD_211 209 0 100meg
R_PD_212 N178 0 100meg
R_PD_213 130 0 100meg
R_PD_214 N307 0 100meg
R_PD_215 152 0 100meg
R_PD_216 N1113 0 100meg
R_PD_217 104 0 100meg
R_PD_218 N10713 0 100meg
R_PD_219 577 0 100meg
R_PD_220 492 0 100meg
R_PD_221 111 0 100meg
R_PD_222 237 0 100meg
R_PD_223 277 0 100meg
R_PD_224 N197 0 100meg
R_PD_225 634 0 100meg
R_PD_226 243 0 100meg
R_PD_227 N12 0 100meg
R_PD_228 31 0 100meg
R_PD_229 445 0 100meg
R_PD_230 547 0 100meg
R_PD_231 N230 0 100meg
R_PD_232 649 0 100meg
R_PD_233 N283 0 100meg
R_PD_234 159 0 100meg
R_PD_235 672 0 100meg
R_PD_236 389 0 100meg
R_PD_237 465 0 100meg
R_PD_238 27 0 100meg
R_PD_239 N1781 0 100meg
R_PD_240 N10839 0 100meg
R_PD_241 682 0 100meg
R_PD_242 78 0 100meg
R_PD_243 N177 0 100meg
R_PD_244 323 0 100meg
R_PD_245 N364 0 100meg
R_PD_246 N10628 0 100meg
R_PD_247 N154 0 100meg
R_PD_248 366 0 100meg
R_PD_249 611 0 100meg
R_PD_250 13 0 100meg
R_PD_251 381 0 100meg
R_PD_252 N10837 0 100meg
R_PD_253 N274 0 100meg
R_PD_254 N367 0 100meg
R_PD_255 346 0 100meg
R_PD_256 178 0 100meg
R_PD_257 568 0 100meg
R_PD_258 524 0 100meg
R_PD_259 N182 0 100meg
R_PD_260 659 0 100meg
R_PD_261 655 0 100meg
R_PD_262 678 0 100meg
R_PD_263 N32 0 100meg
R_PD_264 484 0 100meg
R_PD_265 162 0 100meg
R_PD_266 N63 0 100meg
R_PD_267 517 0 100meg
R_PD_268 N173 0 100meg
R_PD_269 405 0 100meg
R_PD_270 N130 0 100meg
R_PD_271 300 0 100meg
R_PD_272 386 0 100meg
R_PD_273 253 0 100meg
R_PD_274 N10905 0 100meg
R_PD_275 21 0 100meg
R_PD_276 269 0 100meg
R_PD_277 382 0 100meg
R_PD_278 N10352 0 100meg
R_PD_279 N205 0 100meg
R_PD_280 342 0 100meg
R_PD_281 169 0 100meg
R_PD_282 N232 0 100meg
R_PD_283 331 0 100meg
R_PD_284 N236 0 100meg
R_PD_285 357 0 100meg
R_PD_286 N223 0 100meg
R_PD_287 440 0 100meg
R_PD_288 562 0 100meg
R_PD_289 452 0 100meg
R_PD_290 65 0 100meg
R_PD_291 N343 0 100meg
R_PD_292 N53 0 100meg
R_PD_293 597 0 100meg
R_PD_294 718 0 100meg
R_PD_295 N109 0 100meg
R_PD_296 327 0 100meg
R_PD_297 87 0 100meg
R_PD_298 470 0 100meg
R_PD_299 280 0 100meg
R_PD_300 N325 0 100meg
R_PD_301 N151 0 100meg
R_PD_302 344 0 100meg
R_PD_303 136 0 100meg
R_PD_304 477 0 100meg
R_PD_305 498 0 100meg
R_PD_306 N235 0 100meg
R_PD_307 598 0 100meg
R_PD_308 668 0 100meg
R_PD_309 N10575 0 100meg
R_PD_310 466 0 100meg
R_PD_311 N115 0 100meg
R_PD_312 586 0 100meg
R_PD_313 N171 0 100meg
R_PD_314 232 0 100meg
R_PD_315 500 0 100meg
R_PD_316 244 0 100meg
R_PD_317 66 0 100meg
R_PD_318 580 0 100meg
R_PD_319 615 0 100meg
R_PD_320 51 0 100meg
R_PD_321 349 0 100meg
R_PD_322 415 0 100meg
R_PD_323 407 0 100meg
R_PD_324 26 0 100meg
R_PD_325 279 0 100meg
R_PD_326 554 0 100meg
R_PD_327 339 0 100meg
R_PD_328 107 0 100meg
R_PD_329 1 0 100meg
R_PD_330 100 0 100meg
R_PD_331 301 0 100meg
R_PD_332 525 0 100meg
R_PD_333 235 0 100meg
R_PD_334 662 0 100meg
R_PD_335 544 0 100meg
R_PD_336 116 0 100meg
R_PD_337 N10718 0 100meg
R_PD_338 267 0 100meg
R_PD_339 372 0 100meg
R_PD_340 N10760 0 100meg
R_PD_341 686 0 100meg
R_PD_342 N152 0 100meg
R_PD_343 425 0 100meg
R_PD_344 601 0 100meg
R_PD_345 420 0 100meg
R_PD_346 N163 0 100meg
R_PD_347 293 0 100meg
R_PD_348 591 0 100meg
R_PD_349 N198 0 100meg
R_PD_350 144 0 100meg
R_PD_351 584 0 100meg
R_PD_352 89 0 100meg
R_PD_353 153 0 100meg
R_PD_354 332 0 100meg
R_PD_355 N10576 0 100meg
R_PD_356 121 0 100meg
R_PD_357 149 0 100meg
R_PD_358 97 0 100meg
R_PD_359 698 0 100meg
R_PD_360 N289 0 100meg
R_PD_361 495 0 100meg
R_PD_362 15 0 100meg
R_PD_363 N10715 0 100meg
R_PD_364 314 0 100meg
R_PD_365 238 0 100meg
R_PD_366 N11334 0 100meg
R_PD_367 4 0 100meg
R_PD_368 623 0 100meg
R_PD_369 N1 0 100meg
R_PD_370 574 0 100meg
R_PD_371 455 0 100meg
R_PD_372 N211 0 100meg
R_PD_373 360 0 100meg
R_PD_374 N176 0 100meg
R_PD_375 375 0 100meg
R_PD_376 592 0 100meg
R_PD_377 N179 0 100meg
R_PD_378 N10906 0 100meg
R_PD_379 433 0 100meg
R_PD_380 201 0 100meg
R_PD_381 N85 0 100meg
R_PD_382 7 0 100meg
R_PD_383 231 0 100meg
R_PD_384 246 0 100meg
R_PD_385 419 0 100meg
R_PD_386 442 0 100meg
R_PD_387 N229 0 100meg
R_PD_388 207 0 100meg
R_PD_389 150 0 100meg
R_PD_390 370 0 100meg
R_PD_391 408 0 100meg
R_PD_392 N64 0 100meg
R_PD_393 337 0 100meg
R_PD_394 665 0 100meg
R_PD_395 520 0 100meg
R_PD_396 N124 0 100meg
R_PD_397 N160 0 100meg
R_PD_398 715 0 100meg
R_PD_399 N61 0 100meg
R_PD_400 N225 0 100meg
R_PD_401 254 0 100meg
R_PD_402 N355 0 100meg
R_PD_403 N75 0 100meg
R_PD_404 473 0 100meg
R_PD_405 306 0 100meg
R_PD_406 417 0 100meg
R_PD_407 N155 0 100meg
R_PD_408 316 0 100meg
R_PD_409 263 0 100meg
R_PD_410 192 0 100meg
R_PD_411 309 0 100meg
R_PD_412 395 0 100meg
R_PD_413 399 0 100meg
R_PD_414 579 0 100meg
R_PD_415 N242 0 100meg
R_PD_416 N66 0 100meg
R_PD_417 34 0 100meg
R_PD_418 298 0 100meg
R_PD_419 219 0 100meg
R_PD_420 N340 0 100meg
R_PD_421 393 0 100meg
R_PD_422 614 0 100meg
R_PD_423 581 0 100meg
R_PD_424 N233 0 100meg
R_PD_425 367 0 100meg
R_PD_426 543 0 100meg
R_PD_427 241 0 100meg
R_PD_428 290 0 100meg
R_PD_429 426 0 100meg
R_PD_430 639 0 100meg
R_PD_431 299 0 100meg
R_PD_432 603 0 100meg
R_PD_433 534 0 100meg
R_PD_434 245 0 100meg
R_PD_435 N44 0 100meg
R_PD_436 172 0 100meg
R_PD_437 673 0 100meg
R_PD_438 N150 0 100meg
R_PD_439 223 0 100meg
R_PD_440 190 0 100meg
R_PD_441 461 0 100meg
R_PD_442 531 0 100meg
R_PD_443 538 0 100meg
R_PD_444 N181 0 100meg
R_PD_445 252 0 100meg
R_PD_446 438 0 100meg
R_PD_447 88 0 100meg
R_PD_448 N86 0 100meg
R_PD_449 609 0 100meg
R_PD_450 N10759 0 100meg
R_PD_451 93 0 100meg
R_PD_452 N260 0 100meg
R_PD_453 N118 0 100meg
R_PD_454 335 0 100meg
R_PD_455 490 0 100meg
R_PD_456 621 0 100meg
R_PD_457 N83 0 100meg
R_PD_458 508 0 100meg
R_PD_459 494 0 100meg
R_PD_460 249 0 100meg
R_PD_461 251 0 100meg
R_PD_462 32 0 100meg
R_PD_463 371 0 100meg
R_PD_464 N263 0 100meg
R_PD_465 182 0 100meg
R_PD_466 14 0 100meg
R_PD_467 N10350 0 100meg
R_PD_468 599 0 100meg
R_PD_469 446 0 100meg
R_PD_470 175 0 100meg
R_PD_471 N10717 0 100meg
R_PD_472 624 0 100meg
R_PD_473 N26 0 100meg
R_PD_474 84 0 100meg
R_PD_475 274 0 100meg
R_PD_476 486 0 100meg
R_PD_477 N251 0 100meg
R_PD_478 664 0 100meg
R_PD_479 185 0 100meg
R_PD_480 489 0 100meg
R_PD_481 422 0 100meg
R_PD_482 651 0 100meg
R_PD_483 488 0 100meg
R_PD_484 430 0 100meg
R_PD_485 681 0 100meg
R_PD_486 522 0 100meg
R_PD_487 191 0 100meg
R_PD_488 296 0 100meg
R_PD_489 680 0 100meg
R_PD_490 N10102 0 100meg
R_PD_491 N196 0 100meg
R_PD_492 660 0 100meg
R_PD_493 N15 0 100meg
R_PD_494 454 0 100meg
R_PD_495 400 0 100meg
R_PD_496 608 0 100meg
R_PD_497 N214 0 100meg
R_PD_498 691 0 100meg
R_PD_499 176 0 100meg
R_PD_500 N81 0 100meg
R_PD_501 295 0 100meg
R_PD_502 N382 0 100meg
R_PD_503 N231 0 100meg
R_PD_504 194 0 100meg
R_PD_505 633 0 100meg
R_PD_506 N88 0 100meg
R_PD_507 233 0 100meg
R_PD_508 358 0 100meg
R_PD_509 N59 0 100meg
R_PD_510 535 0 100meg
R_PD_511 411 0 100meg
R_PD_512 317 0 100meg
R_PD_513 234 0 100meg
R_PD_514 474 0 100meg
R_PD_515 148 0 100meg
R_PD_516 716 0 100meg
R_PD_517 428 0 100meg
R_PD_518 507 0 100meg
R_PD_519 656 0 100meg
R_PD_520 390 0 100meg
R_PD_521 696 0 100meg
R_PD_522 533 0 100meg
R_PD_523 N157 0 100meg
R_PD_524 431 0 100meg
R_PD_525 60 0 100meg
R_PD_526 266 0 100meg
R_PD_527 55 0 100meg
R_PD_528 553 0 100meg
R_PD_529 N277 0 100meg
R_PD_530 642 0 100meg
R_PD_531 39 0 100meg
R_PD_532 N885 0 100meg
R_PD_533 18 0 100meg
R_PD_534 179 0 100meg
R_PD_535 N240 0 100meg
R_PD_536 126 0 100meg
R_PD_537 158 0 100meg
R_PD_538 N245 0 100meg
R_PD_539 401 0 100meg
R_PD_540 540 0 100meg
R_PD_541 710 0 100meg
R_PD_542 462 0 100meg
R_PD_543 N10711 0 100meg
R_PD_544 137 0 100meg
R_PD_545 23 0 100meg
R_PD_546 30 0 100meg
R_PD_547 221 0 100meg
R_PD_548 167 0 100meg
R_PD_549 650 0 100meg
R_PD_550 647 0 100meg
R_PD_551 132 0 100meg
R_PD_552 N10704 0 100meg
R_PD_553 N87 0 100meg
R_PD_554 29 0 100meg
R_PD_555 N113 0 100meg
R_PD_556 351 0 100meg
R_PD_557 90 0 100meg
R_PD_558 491 0 100meg
R_PD_559 294 0 100meg
R_PD_560 N18 0 100meg
R_PD_561 347 0 100meg
R_PD_562 6 0 100meg
R_PD_563 216 0 100meg
R_PD_564 402 0 100meg
R_PD_565 146 0 100meg
R_PD_566 N11340 0 100meg
R_PD_567 N38 0 100meg
R_PD_568 N10112 0 100meg
R_PD_569 64 0 100meg
R_PD_570 641 0 100meg
R_PD_571 705 0 100meg
R_PD_572 706 0 100meg
R_PD_573 N310 0 100meg
R_PD_574 526 0 100meg
R_PD_575 717 0 100meg
R_PD_576 73 0 100meg
R_PD_577 164 0 100meg
R_PD_578 707 0 100meg
R_PD_579 N69 0 100meg
R_PD_580 N156 0 100meg
R_PD_581 N10870 0 100meg
R_PD_582 384 0 100meg
R_PD_583 374 0 100meg
R_PD_584 441 0 100meg
R_PD_585 432 0 100meg
R_PD_586 156 0 100meg
R_PD_587 264 0 100meg
R_PD_588 131 0 100meg
R_PD_589 N220 0 100meg
R_PD_590 449 0 100meg
R_PD_591 N10868 0 100meg
R_PD_592 N41 0 100meg
R_PD_593 115 0 100meg
R_PD_594 160 0 100meg
R_PD_595 N296 0 100meg
R_PD_596 397 0 100meg
R_PD_597 450 0 100meg
R_PD_598 N201 0 100meg
R_PD_599 186 0 100meg
R_PD_600 N55 0 100meg
R_PD_601 497 0 100meg
R_PD_602 635 0 100meg
R_PD_603 147 0 100meg
R_PD_604 74 0 100meg
R_PD_605 421 0 100meg
R_PD_606 46 0 100meg
R_PD_607 247 0 100meg
R_PD_608 403 0 100meg
R_PD_609 198 0 100meg
R_PD_610 N238 0 100meg
R_PD_611 N331 0 100meg
R_PD_612 170 0 100meg
R_PD_613 173 0 100meg
R_PD_614 288 0 100meg
R_PD_615 674 0 100meg
R_PD_616 124 0 100meg
R_PD_617 N10353 0 100meg
R_PD_618 240 0 100meg
R_PD_619 552 0 100meg
R_PD_620 8 0 100meg
R_PD_621 N56 0 100meg
R_PD_622 N1110 0 100meg
R_PD_623 N207 0 100meg
R_PD_624 227 0 100meg
R_PD_625 265 0 100meg
R_PD_626 99 0 100meg
R_PD_627 N10025 0 100meg
R_PD_628 N337 0 100meg
R_PD_629 515 0 100meg
R_PD_630 199 0 100meg
R_PD_631 532 0 100meg
R_PD_632 511 0 100meg
R_PD_633 54 0 100meg
R_PD_634 108 0 100meg
R_PD_635 217 0 100meg
R_PD_636 555 0 100meg
R_PD_637 N882 0 100meg
R_PD_638 575 0 100meg
R_PD_639 112 0 100meg
R_PD_640 578 0 100meg
R_PD_641 283 0 100meg
R_PD_642 86 0 100meg
R_PD_643 604 0 100meg
R_PD_644 N121 0 100meg
R_PD_645 677 0 100meg
R_PD_646 28 0 100meg
R_PD_647 120 0 100meg
R_PD_648 226 0 100meg
R_PD_649 N195 0 100meg
R_PD_650 693 0 100meg
R_PD_651 118 0 100meg
R_PD_652 212 0 100meg
R_PD_653 338 0 100meg
R_PD_654 303 0 100meg
R_PD_655 620 0 100meg
R_PD_656 33 0 100meg
R_PD_657 458 0 100meg
R_PD_658 N78 0 100meg
R_PD_659 98 0 100meg
R_PD_660 391 0 100meg
R_PD_661 297 0 100meg
R_PD_662 N10714 0 100meg
R_PD_663 N202 0 100meg
R_PD_664 654 0 100meg
R_PD_665 392 0 100meg
R_PD_666 583 0 100meg
R_PD_667 94 0 100meg
R_PD_668 171 0 100meg
R_PD_669 571 0 100meg
R_PD_670 N267 0 100meg
R_PD_671 155 0 100meg
R_PD_672 N218 0 100meg
R_PD_673 348 0 100meg
R_PD_674 379 0 100meg
R_PD_675 618 0 100meg
R_PD_676 N168 0 100meg
R_PD_677 N204 0 100meg
R_PD_678 273 0 100meg
R_PD_679 189 0 100meg
R_PD_680 376 0 100meg
R_PD_681 434 0 100meg
R_PD_682 N183 0 100meg
R_PD_683 139 0 100meg
R_PD_684 661 0 100meg
R_PD_685 80 0 100meg
R_PD_686 286 0 100meg
R_PD_687 292 0 100meg
R_PD_688 606 0 100meg
R_PD_689 637 0 100meg
R_PD_690 45 0 100meg
R_PD_691 N199 0 100meg
R_PD_692 711 0 100meg
R_PD_693 N280 0 100meg
R_PD_694 N73 0 100meg
R_PD_695 N47 0 100meg
R_PD_696 248 0 100meg
R_PD_697 213 0 100meg
R_PD_698 N313 0 100meg
R_PD_699 541 0 100meg
R_PD_700 478 0 100meg
R_PD_701 49 0 100meg
R_PD_702 62 0 100meg
R_PD_703 122 0 100meg
R_PD_704 N127 0 100meg
R_PD_705 506 0 100meg
R_PD_706 631 0 100meg
R_PD_707 N50 0 100meg
R_PD_708 605 0 100meg
R_PD_709 205 0 100meg
R_PD_710 N203 0 100meg
R_PD_711 N170 0 100meg
R_PD_712 220 0 100meg
R_PD_713 N111 0 100meg
R_PD_714 469 0 100meg
R_PD_715 630 0 100meg
R_PD_716 697 0 100meg
R_PD_717 319 0 100meg
R_PD_718 410 0 100meg
R_PD_719 N159 0 100meg
R_PD_720 203 0 100meg
R_PD_721 143 0 100meg
R_PD_722 67 0 100meg
R_PD_723 278 0 100meg
R_PD_724 312 0 100meg
R_PD_725 435 0 100meg
R_PD_726 627 0 100meg
R_PD_727 567 0 100meg
R_PD_728 685 0 100meg
R_PD_729 272 0 100meg
R_PD_730 N10869 0 100meg
R_PD_731 281 0 100meg
R_PD_732 670 0 100meg
R_PD_733 291 0 100meg
R_PD_734 340 0 100meg
R_PD_735 328 0 100meg
R_PD_736 N319 0 100meg
R_PD_737 588 0 100meg
R_PD_738 N192 0 100meg
R_PD_739 5 0 100meg
R_PD_740 482 0 100meg
R_PD_741 566 0 100meg
R_PD_742 699 0 100meg
R_PD_743 101 0 100meg
R_PD_744 537 0 100meg
R_PD_745 174 0 100meg
R_PD_746 N76 0 100meg
R_PD_747 487 0 100meg
R_PD_748 N169 0 100meg
R_PD_749 688 0 100meg
R_PD_750 N10101 0 100meg
R_PD_751 N293 0 100meg
R_PD_752 258 0 100meg
R_PD_753 N322 0 100meg
R_PD_754 N62 0 100meg
R_PD_755 N358 0 100meg
R_PD_756 69 0 100meg
R_PD_757 510 0 100meg
R_PD_758 50 0 100meg
R_PD_759 184 0 100meg
R_PD_760 N208 0 100meg
R_PD_761 110 0 100meg
R_PD_762 619 0 100meg
R_PD_763 N222 0 100meg
R_PD_764 436 0 100meg
R_PD_765 119 0 100meg
R_PD_766 683 0 100meg
R_PD_767 587 0 100meg
R_PD_768 N190 0 100meg
R_PD_769 181 0 100meg
R_PD_770 N224 0 100meg
R_PD_771 24 0 100meg
R_PD_772 57 0 100meg
R_PD_773 N103 0 100meg
R_PD_774 9 0 100meg
R_PD_775 675 0 100meg
R_PD_776 N112 0 100meg
R_PD_777 12 0 100meg
R_PD_778 377 0 100meg
R_PD_779 459 0 100meg
R_PD_780 140 0 100meg
R_PD_781 N227 0 100meg
R_PD_782 513 0 100meg
R_PD_783 N188 0 100meg
R_PD_784 N328 0 100meg
R_PD_785 610 0 100meg
R_PD_786 103 0 100meg
R_PD_787 451 0 100meg
R_PD_788 687 0 100meg
R_PD_789 40 0 100meg
R_PD_790 593 0 100meg
R_PD_791 595 0 100meg
R_PD_792 195 0 100meg
R_PD_793 629 0 100meg
R_PD_794 N349 0 100meg
R_PD_795 456 0 100meg
R_PD_796 285 0 100meg
R_PD_797 N213 0 100meg
R_PD_798 83 0 100meg
R_PD_799 N237 0 100meg
R_PD_800 N206 0 100meg
R_PD_801 643 0 100meg
R_PD_802 676 0 100meg
R_PD_803 N138 0 100meg
R_PD_804 418 0 100meg
R_PD_805 N175 0 100meg
R_PD_806 N1111 0 100meg
R_PD_807 569 0 100meg
R_PD_808 210 0 100meg
R_PD_809 447 0 100meg
R_PD_810 2 0 100meg
R_PD_811 N216 0 100meg
R_PD_812 536 0 100meg
R_PD_813 N54 0 100meg
R_PD_814 308 0 100meg
R_PD_815 429 0 100meg
R_PD_816 341 0 100meg
R_PD_817 N10908 0 100meg
R_PD_818 N5 0 100meg
R_PD_819 453 0 100meg
R_PD_820 628 0 100meg
R_PD_821 75 0 100meg
R_PD_822 394 0 100meg
R_PD_823 N212 0 100meg
R_PD_824 N184 0 100meg
R_PD_825 141 0 100meg
R_PD_826 518 0 100meg
R_PD_827 460 0 100meg
R_PD_828 463 0 100meg
R_PD_829 N257 0 100meg
R_PD_830 N158 0 100meg
R_PD_831 356 0 100meg
R_PD_832 N10110 0 100meg
R_PD_833 527 0 100meg
R_PD_834 82 0 100meg
R_PD_835 105 0 100meg
R_PD_836 168 0 100meg
R_PD_837 590 0 100meg
R_PD_838 N57 0 100meg
R_PD_839 N228 0 100meg
R_PD_840 496 0 100meg
R_PD_841 362 0 100meg
R_PD_842 457 0 100meg
R_PD_843 N10827 0 100meg
R_PD_844 636 0 100meg
R_PD_845 640 0 100meg
R_PD_846 85 0 100meg
R_PD_847 481 0 100meg
R_PD_848 607 0 100meg
R_PD_849 N248 0 100meg
R_PD_850 311 0 100meg
R_PD_851 79 0 100meg
R_PD_852 695 0 100meg
R_PD_853 378 0 100meg
R_PD_854 644 0 100meg
R_PD_855 700 0 100meg
R_PD_856 479 0 100meg
R_PD_857 154 0 100meg
R_PD_858 N191 0 100meg
R_PD_859 N80 0 100meg
R_PD_860 204 0 100meg
R_PD_861 N174 0 100meg
R_PD_862 480 0 100meg
R_PD_863 546 0 100meg
R_PD_864 224 0 100meg
R_PD_865 16 0 100meg
R_PD_866 663 0 100meg
R_PD_867 70 0 100meg
R_PD_868 564 0 100meg
R_PD_869 163 0 100meg
R_PD_870 193 0 100meg
R_PD_871 77 0 100meg
R_PD_872 183 0 100meg
R_PD_873 N352 0 100meg
R_PD_874 N303 0 100meg
R_PD_875 N166 0 100meg
R_PD_876 N162 0 100meg
R_PD_877 N10706 0 100meg
R_PD_878 368 0 100meg
R_PD_879 35 0 100meg
R_PD_880 N10762 0 100meg
R_PD_881 666 0 100meg
R_PD_882 653 0 100meg
R_PD_883 188 0 100meg
R_PD_884 N271 0 100meg
R_PD_885 114 0 100meg
R_PD_886 N65 0 100meg
R_PD_887 145 0 100meg
R_PD_888 206 0 100meg
R_PD_889 N11342 0 100meg
R_PD_890 N185 0 100meg
R_PD_891 218 0 100meg
R_PD_892 387 0 100meg
R_PD_893 582 0 100meg
R_PD_894 585 0 100meg
R_PD_895 657 0 100meg
R_PD_896 669 0 100meg
R_PD_897 714 0 100meg
R_PD_898 667 0 100meg
R_PD_899 N10729 0 100meg
R_PD_900 385 0 100meg
R_PD_901 646 0 100meg
R_PD_902 N10712 0 100meg
R_PD_903 N316 0 100meg
R_PD_904 N135 0 100meg
R_PD_905 197 0 100meg
R_PD_906 499 0 100meg
R_PD_907 N226 0 100meg
R_PD_908 N215 0 100meg
R_PD_909 N161 0 100meg
R_PD_910 47 0 100meg
R_PD_911 326 0 100meg
R_PD_912 505 0 100meg
R_PD_913 N10574 0 100meg
R_PD_914 63 0 100meg
R_PD_915 81 0 100meg
R_PD_916 315 0 100meg
R_PD_917 42 0 100meg
R_PD_918 336 0 100meg
R_PD_919 576 0 100meg
R_PD_920 561 0 100meg
R_PD_921 333 0 100meg
R_PD_922 123 0 100meg
R_PD_923 602 0 100meg
R_PD_924 25 0 100meg
R_PD_925 359 0 100meg
R_PD_926 626 0 100meg
R_PD_927 439 0 100meg
R_PD_928 427 0 100meg
R_PD_929 305 0 100meg
R_PD_930 284 0 100meg
R_PD_931 N881 0 100meg
R_PD_932 N187 0 100meg
R_PD_933 N10716 0 100meg
R_PD_934 N186 0 100meg
R_PD_935 289 0 100meg
R_PD_936 542 0 100meg
R_PD_937 645 0 100meg
R_PD_938 N58 0 100meg
R_PD_939 334 0 100meg
R_PD_940 N165 0 100meg
R_PD_941 196 0 100meg
R_PD_942 572 0 100meg
R_PD_943 268 0 100meg
R_PD_944 270 0 100meg
R_PD_945 373 0 100meg
R_PD_946 521 0 100meg
R_PD_947 19 0 100meg
R_PD_948 250 0 100meg
R_PD_949 N11333 0 100meg
R_PD_950 N70 0 100meg
R_PD_951 361 0 100meg
R_PD_952 414 0 100meg
R_PD_953 444 0 100meg
R_PD_954 N286 0 100meg
R_PD_955 448 0 100meg
R_PD_956 N219 0 100meg
R_PD_957 570 0 100meg
R_PD_958 129 0 100meg
R_PD_959 95 0 100meg
R_PD_960 329 0 100meg
R_PD_961 352 0 100meg
R_PD_962 353 0 100meg
R_PD_963 701 0 100meg
R_PD_964 692 0 100meg
R_PD_965 N10104 0 100meg
R_PD_966 N164 0 100meg
R_PD_967 N10761 0 100meg
R_PD_968 N141 0 100meg
R_PD_969 412 0 100meg
R_PD_970 345 0 100meg
R_PD_971 320 0 100meg
R_PD_972 91 0 100meg
R_PD_973 380 0 100meg
R_PD_974 282 0 100meg
R_PD_975 423 0 100meg
R_PD_976 493 0 100meg
R_PD_977 388 0 100meg
R_PD_978 679 0 100meg
R_PD_979 11 0 100meg
R_PD_980 133 0 100meg
R_PD_981 N180 0 100meg

* Transient Simulation Directive
.TRAN 100p 10n
