* Nangila SPICE Auto-Synthesized Netlist
.SUBCKT INV_X1 A Z
M1 Z A 0 0 NMOS W=0.2u L=0.05u
M2 Z A 1 1 PMOS W=0.4u L=0.05u
.ENDS

.SUBCKT NAND2_X1 A1 A2 Z
M1 Z A1 1 1 PMOS W=0.4u L=0.05u
M2 Z A2 1 1 PMOS W=0.4u L=0.05u
M3 Z A1 int 0 NMOS W=0.2u L=0.05u
M4 int A2 0 0 NMOS W=0.2u L=0.05u
.ENDS

.SUBCKT AND2_X1 A1 A2 Z
X1 A1 A2 Z_bar NAND2_X1
X2 Z_bar Z INV_X1
.ENDS

.SUBCKT NOR2_X1 A1 A2 Z
M1 int1 A1 1 1 PMOS W=0.4u L=0.05u
M2 Z A2 int1 1 PMOS W=0.4u L=0.05u
M3 Z A1 0 0 NMOS W=0.2u L=0.05u
M4 Z A2 0 0 NMOS W=0.2u L=0.05u
.ENDS

.SUBCKT OR2_X1 A1 A2 Z
X1 A1 A2 Z_bar NOR2_X1
X2 Z_bar Z INV_X1
.ENDS

.SUBCKT XOR2_X1 A1 A2 Z
X1 A1 A2 int1 AND2_X1
X2 A1 A2 int2 NOR2_X1
X3 int1 int2 int3 NOR2_X1
X4 int3 Z INV_X1
.ENDS

.SUBCKT XNOR2_X1 A B Z
X1 A B Z_int XOR2_X1
X2 Z_int Z INV_X1
.ENDS

.SUBCKT BUF_X1 A Z
X1 A Z_bar INV_X1
X2 Z_bar Z INV_X1
.ENDS

.SUBCKT OAI21_X1 A B C Z
X1 A B C Z_bar AOI21_X1
X2 Z_bar Z INV_X1
.ENDS

.SUBCKT AOI21_X1 A B C Z
M1 Z A int1 1 PMOS W=0.4u L=0.05u
M2 int1 B 1 1 PMOS W=0.4u L=0.05u
M3 Z C 1 1 PMOS W=0.4u L=0.05u
M4 Z A 0 0 NMOS W=0.2u L=0.05u
M5 Z B 0 0 NMOS W=0.2u L=0.05u
M6 Z C 0 0 NMOS W=0.2u L=0.05u
.ENDS

.SUBCKT NAND3_X1 A1 A2 A3 Z
X1 A1 A2 int1 AND2_X1
X2 int1 A3 Z NAND2_X1
.ENDS

.SUBCKT AND3_X1 A1 A2 A3 Z
X1 A1 A2 A3 Z_bar NAND3_X1
X2 Z_bar Z INV_X1
.ENDS

.SUBCKT NOR3_X1 A1 A2 A3 Z
X1 A1 A2 int1 OR2_X1
X2 int1 A3 Z NOR2_X1
.ENDS

.SUBCKT OR3_X1 A1 A2 A3 Z
X1 A1 A2 A3 Z_bar NOR3_X1
X2 Z_bar Z INV_X1
.ENDS

.SUBCKT NAND4_X1 A1 A2 A3 A4 Z
X1 A1 A2 A3 int1 AND3_X1
X2 int1 A4 Z NAND2_X1
.ENDS

.SUBCKT AND4_X1 A1 A2 A3 A4 Z
X1 A1 A2 A3 A4 Z_bar NAND4_X1
X2 Z_bar Z INV_X1
.ENDS

.SUBCKT NOR4_X1 A1 A2 A3 A4 Z
X1 A1 A2 A3 int1 OR3_X1
X2 int1 A4 Z NOR2_X1
.ENDS

.SUBCKT OR4_X1 A1 A2 A3 A4 Z
X1 A1 A2 A3 A4 Z_bar NOR4_X1
X2 Z_bar Z INV_X1
.ENDS

.SUBCKT AOI22_X1 A B C D Z
X1 A B int1 AND2_X1
X2 C D int2 AND2_X1
X3 int1 int2 Z NOR2_X1
.ENDS

.SUBCKT OAI22_X1 A B C D Z
X1 A B int1 OR2_X1
X2 C D int2 OR2_X1
X3 int1 int2 Z NAND2_X1
.ENDS

.SUBCKT AOI211_X1 A B C D Z
X1 A B int1 AND2_X1
X2 int1 C D Z NOR3_X1
.ENDS

.SUBCKT OAI211_X1 A B C D Z
X1 A B int1 OR2_X1
X2 int1 C D Z NAND3_X1
.ENDS

.SUBCKT OAI33_X1 A B C D E F Z
X1 A B C int1 OR3_X1
X2 D E F int2 OR3_X1
X3 int1 int2 Z NAND2_X1
.ENDS

.SUBCKT AOI33_X1 A B C D E F Z
X1 A B C int1 AND3_X1
X2 D E F int2 AND3_X1
X3 int1 int2 Z NOR2_X1
.ENDS

.SUBCKT MUX2_X1 A B S Z
X1 S S_bar INV_X1
X2 A S_bar int1 AND2_X1
X3 B S int2 AND2_X1
X4 int1 int2 Z OR2_X1
.ENDS

.SUBCKT DFF_X1 D C Q QN
X1 D Q_int INV_X1
X2 Q_int Q INV_X1
X3 Q_int QN INV_X1
.ENDS

.SUBCKT DFFR_X1 D C RN Q QN
X1 D Q_int INV_X1
X2 Q_int Q INV_X1
X3 Q_int QN INV_X1
.ENDS

.SUBCKT DFFS_X1 C D Q QN SN
X1 D Q_int INV_X1
X2 Q_int Q INV_X1
X3 Q_int QN INV_X1
.ENDS

.SUBCKT DFFRS_X1 C D Q QN RN SN
X1 D Q_int INV_X1
X2 Q_int Q INV_X1
X3 Q_int QN INV_X1
.ENDS

* Provide VDD power source explicitly
Vvdd 1 0 1.8

* Auto-extracted Inputs:
V_N1 N1 0 1.8
V_N13 N13 0 0.0
V_N20 N20 0 1.8
V_N33 N33 0 0.0
V_N41 N41 0 1.8
V_N45 N45 0 0.0
V_N50 N50 0 1.8
V_N58 N58 0 0.0
V_N68 N68 0 1.8
V_N77 N77 0 0.0
V_N87 N87 0 1.8
V_N97 N97 0 0.0
V_N107 N107 0 1.8
V_N116 N116 0 0.0
V_N124 N124 0 1.8
V_N125 N125 0 0.0
V_N128 N128 0 1.8
V_N132 N132 0 0.0
V_N137 N137 0 1.8
V_N143 N143 0 0.0
V_N150 N150 0 1.8
V_N159 N159 0 0.0
V_N169 N169 0 1.8
V_N179 N179 0 0.0
V_N190 N190 0 1.8
V_N200 N200 0 0.0
V_N213 N213 0 1.8
V_N222 N222 0 0.0
V_N223 N223 0 1.8
V_N226 N226 0 0.0
V_N232 N232 0 1.8
V_N238 N238 0 0.0
V_N244 N244 0 1.8
V_N250 N250 0 0.0
V_N257 N257 0 1.8
V_N264 N264 0 0.0
V_N270 N270 0 1.8
V_N274 N274 0 0.0
V_N283 N283 0 1.8
V_N294 N294 0 0.0
V_N303 N303 0 1.8
V_N311 N311 0 0.0
V_N317 N317 0 1.8
V_N322 N322 0 0.0
V_N326 N326 0 1.8
V_N329 N329 0 0.0
V_N330 N330 0 1.8
V_N343 N343 0 0.0
V_N349 N349 0 1.8
V_N350 N350 0 0.0

* Yosys Generated Netlist:
* SPICE netlist generated by Yosys 0.62 (git sha1 7326bb7d6641500ecb285c291a54a662cb1e76cf, clang++ 17.0.0 -fPIC -O3)

X0 N257 1 INV_X1
X1 N20 2 INV_X1
X2 N33 3 INV_X1
X3 N41 4 INV_X1
X4 N45 5 INV_X1
X5 N200 6 INV_X1
X6 N179 7 INV_X1
X7 N1 8 INV_X1
X8 N169 9 INV_X1
X9 N226 10 INV_X1
X10 N50 11 INV_X1
X11 N232 12 INV_X1
X12 N238 13 INV_X1
X13 N244 14 INV_X1
X14 N77 15 INV_X1
X15 N97 16 INV_X1
X16 N270 17 INV_X1
X17 N190 18 INV_X1
X18 N343 19 INV_X1
X19 N350 20 INV_X1
X20 N330 21 INV_X1
X21 N50 N58 N68 22 NOR3_X1
X22 15 22 N1713 AND2_X1
X23 N87 N97 N107 N1947 OAI21_X1
X24 N238 N244 23 XNOR2_X1
X25 N226 N232 24 XNOR2_X1
X26 23 24 25 XNOR2_X1
X27 N257 N264 26 XOR2_X1
X28 N250 N270 27 XOR2_X1
X29 26 27 28 XNOR2_X1
X30 25 28 N3833 XNOR2_X1
X31 N13 N1 29 AND2_X1
X32 N13 N1 30 NAND2_X1
X33 N20 N1 31 NAND2_X1
X34 N20 N33 N1 32 AND3_X1
X35 N20 N33 N1 33 NAND3_X1
X36 29 32 34 NOR2_X1
X37 30 33 35 NAND2_X1
X38 N20 N33 36 NOR2_X1
X39 N87 N97 N107 37 OR3_X1
X40 N20 3 16 38 NOR3_X1
X41 38 36 N68 N20 37 39 AOI221_X1
X42 N13 N20 40 NAND2_X1
X43 N1 40 41 NOR2_X1
X44 N1 40 42 OR2_X1
X45 N33 N20 N13 43 AOI21_X1
X46 N1 43 44 OR2_X1
X47 N87 34 44 45 NAND3_X1
X48 45 39 34 N87 42 46 OAI221_X1
X49 N33 N349 47 NOR2_X1
X50 N33 N349 48 OR2_X1
X51 3 N349 N244 49 NAND3_X1
X52 N33 N41 50 AND2_X1
X53 N33 N41 51 NAND2_X1
X54 30 50 52 NOR2_X1
X55 29 51 53 NAND2_X1
X56 N33 N116 47 N238 54 AOI22_X1
X57 49 52 54 55 AND3_X1
X58 49 52 54 56 NAND3_X1
X59 N45 8 N274 57 NAND3_X1
X60 N250 N1 5 58 OAI21_X1
X61 53 57 58 59 AND3_X1
X62 53 57 58 60 NAND3_X1
X63 56 60 61 NAND2_X1
X64 7 56 60 62 AOI21_X1
X65 9 55 59 63 NOR3_X1
X66 46 62 63 64 OAI21_X1
X67 6 55 59 65 NOR3_X1
X68 18 56 60 66 AOI21_X1
X69 46 65 66 67 NOR3_X1
X70 46 65 66 68 OR3_X1
X71 64 68 69 NAND2_X1
X72 3 N349 N250 70 NAND3_X1
X73 N33 N283 71 NAND2_X1
X74 N33 N283 47 N244 72 AOI22_X1
X75 53 70 72 73 AOI21_X1
X76 N41 5 N1 74 NOR3_X1
X77 4 N45 8 75 NAND3_X1
X78 4 N45 8 N274 76 AND4_X1
X79 4 N45 8 N274 77 NAND4_X1
X80 N257 30 50 78 OAI21_X1
X81 77 78 74 79 OAI21_X1
X82 73 79 80 NOR2_X1
X83 73 79 81 OR2_X1
X84 9 73 79 82 OAI21_X1
X85 N97 N107 83 XOR2_X1
X86 N20 83 84 NAND2_X1
X87 N20 N33 N107 85 AOI21_X1
X88 85 15 N33 86 OAI21_X1
X89 35 84 86 87 NAND3_X1
X90 16 41 88 NAND2_X1
X91 N97 34 44 89 NAND3_X1
X92 87 88 89 90 AND3_X1
X93 87 88 89 91 NAND3_X1
X94 82 91 N179 81 92 OAI211_X1
X95 N200 73 79 93 OAI21_X1
X96 90 93 18 81 94 OAI211_X1
X97 92 94 95 NAND2_X1
X98 64 68 92 94 96 NAND4_X1
X99 N20 30 97 NOR2_X1
X100 2 29 98 NAND2_X1
X101 N13 N33 99 OR2_X1
X102 N116 44 98 100 AND3_X1
X103 3 N97 101 NAND2_X1
X104 98 101 71 102 AOI21_X1
X105 N116 42 103 NOR2_X1
X106 100 102 103 104 NOR3_X1
X107 N264 3 N349 105 AND3_X1
X108 N264 3 N349 106 NAND3_X1
X109 N33 N303 107 NAND2_X1
X110 N33 N303 47 N257 108 AOI22_X1
X111 107 48 1 109 OAI21_X1
X112 53 106 108 110 AOI21_X1
X113 52 105 109 111 OAI21_X1
X114 17 29 51 112 AOI21_X1
X115 N270 30 50 113 OAI21_X1
X116 76 112 75 114 AOI21_X1
X117 77 113 74 115 OAI21_X1
X118 110 115 116 NOR2_X1
X119 N169 111 114 117 AOI21_X1
X120 100 102 103 110 115 N179 118 OAI33_X1
X121 117 118 119 NOR2_X1
X122 18 110 115 120 NOR3_X1
X123 104 116 6 121 OAI21_X1
X124 117 118 120 121 122 OAI22_X1
X125 N257 3 N349 123 NAND3_X1
X126 N33 N294 47 N250 124 AOI22_X1
X127 53 123 124 125 AOI21_X1
X128 N264 30 50 126 OAI21_X1
X129 77 126 74 127 OAI21_X1
X130 125 127 128 NOR2_X1
X131 125 127 129 OR2_X1
X132 N179 125 127 130 NOR3_X1
X133 N87 N116 N33 131 MUX2_X1
X134 97 131 132 NAND2_X1
X135 33 40 133 AND2_X1
X136 N107 34 44 134 NAND3_X1
X137 N107 133 135 OR2_X1
X138 132 134 135 136 AND3_X1
X139 132 134 135 137 NAND3_X1
X140 137 128 N169 138 OAI21_X1
X141 130 136 9 129 139 AOI211_X1
X142 N200 125 127 140 OAI21_X1
X143 136 140 18 129 141 OAI211_X1
X144 141 138 130 142 OAI21_X1
X145 96 122 142 143 NOR3_X1
X146 N150 36 144 NAND2_X1
X147 N20 N33 N58 145 AOI21_X1
X148 144 145 22 146 OAI21_X1
X149 29 32 N20 8 147 AOI211_X1
X150 41 147 N50 148 MUX2_X1
X151 148 146 35 149 AOI21_X1
X152 3 N349 N223 150 NAND3_X1
X153 N33 N77 N222 47 151 AOI22_X1
X154 53 150 151 152 AOI21_X1
X155 N41 N45 153 NOR2_X1
X156 8 N274 N41 N45 154 OAI211_X1
X157 30 50 153 N1 155 OAI22_X1
X158 154 155 10 156 OAI21_X1
X159 152 156 157 NOR2_X1
X160 6 18 157 158 MUX2_X1
X161 N169 N179 157 159 MUX2_X1
X162 159 160 INV_X1
X163 149 160 161 NOR2_X1
X164 159 158 149 162 MUX2_X1
X165 3 N349 N226 163 NAND3_X1
X166 N33 N87 N223 47 164 AOI22_X1
X167 53 163 164 165 AOI21_X1
X168 154 155 12 166 OAI21_X1
X169 165 166 167 NOR2_X1
X170 N179 165 166 168 NOR3_X1
X171 N169 167 169 NOR2_X1
X172 41 147 N58 170 MUX2_X1
X173 N159 36 171 NAND2_X1
X174 N58 N68 172 XNOR2_X1
X175 N20 172 173 NAND2_X1
X176 2 N33 N68 174 NAND3_X1
X177 171 173 174 175 NAND3_X1
X178 170 175 35 176 AOI21_X1
X179 168 176 177 OR2_X1
X180 18 165 166 178 NOR3_X1
X181 176 167 6 179 OAI21_X1
X182 169 177 178 179 180 OAI22_X1
X183 N68 147 181 NAND2_X1
X184 11 15 N33 182 MUX2_X1
X185 181 182 98 133 N68 183 OAI221_X1
X186 3 N349 N232 184 NAND3_X1
X187 N33 N97 47 N226 185 AOI22_X1
X188 53 184 185 186 AOI21_X1
X189 154 155 13 187 OAI21_X1
X190 186 187 188 OR2_X1
X191 N190 N200 188 189 MUX2_X1
X192 9 186 187 190 OAI21_X1
X193 183 190 188 N179 191 OAI211_X1
X194 191 189 183 192 OAI21_X1
X195 192 193 INV_X1
X196 3 N349 N238 194 NAND3_X1
X197 N33 N107 47 N232 195 AOI22_X1
X198 53 194 195 196 AOI21_X1
X199 154 155 14 197 OAI21_X1
X200 196 197 198 OR2_X1
X201 9 196 197 199 OAI21_X1
X202 N77 N1 2 200 OAI21_X1
X203 N58 N87 N33 201 MUX2_X1
X204 15 41 97 201 202 AOI22_X1
X205 202 200 97 203 OAI21_X1
X206 199 203 N179 198 204 OAI211_X1
X207 N200 196 197 205 OAI21_X1
X208 18 198 206 NOR2_X1
X209 202 205 97 200 207 OAI211_X1
X210 204 206 207 208 OAI21_X1
X211 162 180 192 208 209 NOR4_X1
X212 209 210 INV_X1
X213 143 209 N4028 AND2_X1
X214 N13 2 8 N213 211 NAND4_X1
X215 211 212 INV_X1
X216 19 211 213 NOR2_X1
X217 N343 212 214 NAND2_X1
X218 139 141 119 215 AOI21_X1
X219 64 92 216 AND2_X1
X220 96 215 216 67 217 OAI22_X1
X221 214 217 218 NAND2_X1
X222 62 80 116 128 219 NAND4_X1
X223 N179 61 116 128 220 NOR4_X1
X224 214 220 81 221 AOI21_X1
X225 21 219 221 222 AOI21_X1
X226 222 213 143 223 OAI21_X1
X227 223 224 INV_X1
X228 218 223 225 NAND2_X1
X229 8 225 226 NAND2_X1
X230 N13 8 227 NOR2_X1
X231 N13 31 228 NOR2_X1
X232 N13 N41 31 229 NOR3_X1
X233 4 228 230 NAND2_X1
X234 N50 N58 N68 231 OAI21_X1
X235 N116 37 232 NOR2_X1
X236 N1 230 232 233 NAND3_X1
X237 226 233 231 230 N4667 OAI211_X1
X238 104 214 234 NOR2_X1
X239 122 234 235 XNOR2_X1
X240 N330 235 236 NAND2_X1
X241 236 237 INV_X1
X242 136 214 238 NOR2_X1
X243 142 238 239 XNOR2_X1
X244 119 214 240 NAND2_X1
X245 142 239 240 241 MUX2_X1
X246 N330 235 239 242 NAND3_X1
X247 213 215 243 NOR2_X1
X248 242 215 213 N4589 OAI21_X1
X249 N20 99 244 NOR2_X1
X250 N20 99 235 245 NOR3_X1
X251 30 9 N20 246 AOI21_X1
X252 29 N169 2 247 OAI21_X1
X253 N20 N179 248 NAND2_X1
X254 N200 18 248 249 NOR3_X1
X255 N20 N200 250 NAND2_X1
X256 N179 N190 250 251 NOR3_X1
X257 248 250 252 NAND2_X1
X258 2 N190 252 253 NOR3_X1
X259 7 18 250 254 NOR3_X1
X260 N179 18 250 255 NOR3_X1
X261 7 N190 250 256 NOR3_X1
X262 252 18 N20 257 AOI21_X1
X263 N200 N190 248 258 NOR3_X1
X264 N322 249 253 N329 257 N294 259 AOI222_X1
X265 N303 255 256 N317 258 N311 260 AOI222_X1
X266 3 N283 251 254 N326 261 AOI221_X1
X267 259 260 261 262 AND3_X1
X268 N107 251 263 NAND2_X1
X269 N97 257 264 NAND2_X1
X270 N33 N159 253 254 N50 265 AOI221_X1
X271 N58 249 258 N77 266 AOI22_X1
X272 N87 255 256 N68 267 AOI22_X1
X273 263 264 266 267 268 AND4_X1
X274 262 265 268 269 AOI21_X1
X275 N13 2 N45 270 AND3_X1
X276 8 2 N13 271 AOI21_X1
X277 8 270 272 OR2_X1
X278 229 272 273 NOR2_X1
X279 244 246 274 NOR2_X1
X280 N68 N77 275 XNOR2_X1
X281 N50 N58 276 XNOR2_X1
X282 275 276 277 XNOR2_X1
X283 N45 231 278 NOR2_X1
X284 N33 228 279 NAND2_X1
X285 278 279 N45 277 280 AOI211_X1
X286 3 N1947 228 281 NAND3_X1
X287 281 228 N116 282 OAI21_X1
X288 274 280 282 283 OAI21_X1
X289 273 283 247 269 284 OAI211_X1
X290 N330 235 272 229 285 OAI22_X1
X291 245 284 285 237 N4815 OAI22_X1
X292 203 213 286 NAND2_X1
X293 208 286 287 XOR2_X1
X294 99 287 288 NOR2_X1
X295 N303 254 256 N283 N116 258 289 AOI222_X1
X296 N294 249 255 N107 290 AOI22_X1
X297 N33 264 289 290 291 NAND4_X1
X298 291 253 N311 N87 251 292 AOI221_X1
X299 N150 256 258 N159 293 AOI22_X1
X300 N143 249 255 N50 294 AOI22_X1
X301 N33 N132 253 254 N137 295 AOI221_X1
X302 293 294 295 296 NAND3_X1
X303 296 251 N68 N58 257 297 AOI221_X1
X304 246 292 297 298 OAI21_X1
X305 99 247 299 NAND2_X1
X306 273 298 299 N77 300 OAI211_X1
X307 208 287 218 301 MUX2_X1
X308 222 287 143 213 302 OAI211_X1
X309 224 301 303 XNOR2_X1
X310 288 300 303 273 N4944 OAI22_X1
X311 176 211 304 NOR2_X1
X312 180 304 305 XNOR2_X1
X313 305 306 INV_X1
X314 183 213 307 NAND2_X1
X315 192 307 308 XOR2_X1
X316 287 308 309 AND2_X1
X317 305 309 310 NAND2_X1
X318 224 310 210 311 OAI21_X1
X319 311 310 210 312 AOI21_X1
X320 169 177 212 313 OR3_X1
X321 193 214 217 287 314 AND4_X1
X322 193 214 217 287 315 NAND4_X1
X323 204 213 316 NOR2_X1
X324 316 189 183 317 OAI21_X1
X325 191 213 318 OR2_X1
X326 317 318 319 NAND2_X1
X327 317 318 320 AND2_X1
X328 306 315 320 321 AOI21_X1
X329 305 314 319 322 OAI21_X1
X330 313 322 323 NAND2_X1
X331 162 180 192 204 324 NOR4_X1
X332 162 180 191 325 NOR3_X1
X333 169 177 149 158 326 AOI211_X1
X334 161 324 325 326 327 NOR4_X1
X335 209 217 328 NAND2_X1
X336 327 328 213 329 OAI21_X1
X337 323 329 330 XNOR2_X1
X338 312 330 331 XOR2_X1
X339 N50 15 172 332 OAI21_X1
X340 227 332 N50 N68 333 OAI211_X1
X341 N20 N116 29 83 334 NAND4_X1
X342 333 334 271 331 N5002 OAI211_X1
X343 91 213 335 NAND2_X1
X344 95 335 336 XNOR2_X1
X345 242 336 337 NOR2_X1
X346 242 336 338 XOR2_X1
X347 243 338 339 XNOR2_X1
X348 236 241 340 XNOR2_X1
X349 340 341 INV_X1
X350 225 272 342 NOR2_X1
X351 225 272 343 OR2_X1
X352 342 341 339 344 OAI21_X1
X353 94 139 345 NAND2_X1
X354 213 345 92 346 AOI21_X1
X355 95 240 347 NOR2_X1
X356 346 347 239 348 AOI21_X1
X357 46 213 349 NAND2_X1
X358 69 349 350 XNOR2_X1
X359 348 350 351 XOR2_X1
X360 337 351 352 XNOR2_X1
X361 273 352 353 NOR2_X1
X362 N159 256 354 NAND2_X1
X363 N97 251 253 N317 355 AOI22_X1
X364 N303 249 254 N311 356 AOI22_X1
X365 N294 256 257 N107 357 AOI22_X1
X366 N116 255 258 N283 358 AOI22_X1
X367 355 356 357 358 359 NAND4_X1
X368 N150 249 255 N58 N50 258 360 AOI222_X1
X369 N33 N137 253 254 N143 361 AOI221_X1
X370 N77 251 257 N68 362 AOI22_X1
X371 354 360 361 362 363 NAND4_X1
X372 363 359 3 364 OAI21_X1
X373 N33 28 228 365 NAND3_X1
X374 N87 31 N13 366 OAI21_X1
X375 274 365 366 367 AND3_X1
X376 367 364 246 244 350 368 AOI221_X1
X377 344 353 368 273 369 AOI22_X1
X378 369 N5045 INV_X1
X379 225 230 370 NOR2_X1
X380 340 370 371 NOR2_X1
X381 229 272 341 343 372 OAI22_X1
X382 N20 99 239 373 NOR3_X1
X383 31 99 232 374 NOR3_X1
X384 279 25 N45 375 AOI21_X1
X385 N45 N68 N77 376 AOI21_X1
X386 11 N58 232 376 377 NAND4_X1
X387 377 375 374 378 OAI21_X1
X388 378 228 N107 379 OAI21_X1
X389 274 379 380 NAND2_X1
X390 N317 249 253 N326 257 N283 381 AOI222_X1
X391 N294 255 256 N311 258 N303 382 AOI222_X1
X392 3 N116 251 254 N322 383 AOI221_X1
X393 381 382 383 384 AND3_X1
X394 N33 N97 251 254 N159 385 AOI221_X1
X395 N50 249 258 N68 386 AOI22_X1
X396 N77 255 256 N58 387 AOI22_X1
X397 386 387 388 NAND2_X1
X398 388 253 N150 N87 257 389 AOI221_X1
X399 384 385 389 390 AOI21_X1
X400 273 380 390 247 391 OAI211_X1
X401 371 372 373 391 N5047 OAI22_X1
X402 244 336 392 NAND2_X1
X403 N68 255 257 N77 N143 253 393 AOI222_X1
X404 N150 254 258 N58 394 AOI22_X1
X405 N159 249 256 N50 395 AOI22_X1
X406 394 395 396 NAND2_X1
X407 N33 396 251 N87 397 AOI211_X1
X408 N116 257 258 N294 N317 254 398 AOI222_X1
X409 N311 249 255 N283 399 AOI22_X1
X410 N322 253 256 N303 400 AOI22_X1
X411 N33 263 399 400 401 AND4_X1
X412 393 397 398 401 402 AOI22_X1
X413 247 402 403 OR2_X1
X414 N107 N116 404 XOR2_X1
X415 N87 N97 405 XNOR2_X1
X416 404 405 406 XNOR2_X1
X417 274 279 406 228 16 407 OAI221_X1
X418 273 392 403 407 408 NAND4_X1
X419 339 340 370 409 NAND3_X1
X420 408 409 339 372 N5078 OAI211_X1
X421 222 309 143 213 410 OAI211_X1
X422 305 314 319 411 NOR3_X1
X423 306 410 412 NOR2_X1
X424 306 410 413 OR2_X1
X425 410 411 321 414 OAI21_X1
X426 413 414 415 AND2_X1
X427 329 224 209 416 AOI21_X1
X428 204 213 218 208 417 OAI22_X1
X429 302 308 418 XOR2_X1
X430 417 418 419 XNOR2_X1
X431 230 416 419 420 AOI21_X1
X432 272 420 421 OR2_X1
X433 229 416 419 422 NAND3_X1
X434 415 422 423 NOR2_X1
X435 99 305 424 NOR2_X1
X436 N132 249 253 N125 257 N159 425 AOI222_X1
X437 N50 251 254 N128 256 N137 426 AOI222_X1
X438 N33 N150 255 258 N143 427 AOI221_X1
X439 425 426 427 428 NAND3_X1
X440 N294 253 256 N107 429 AOI22_X1
X441 N77 257 258 N97 430 AOI22_X1
X442 N68 251 255 N87 431 AOI22_X1
X443 N116 249 254 N283 432 AOI22_X1
X444 429 430 431 432 433 NAND4_X1
X445 428 433 3 434 OAI21_X1
X446 N58 299 435 NOR2_X1
X447 424 435 434 246 436 AOI211_X1
X448 423 436 273 415 421 437 AOI221_X1
X449 437 N5102 INV_X1
X450 419 420 272 438 OAI21_X1
X451 416 420 439 NAND2_X1
X452 99 308 440 NOR2_X1
X453 N283 249 254 N294 256 N116 441 AOI222_X1
X454 N303 253 257 N87 442 AOI22_X1
X455 N77 251 255 N97 443 AOI22_X1
X456 N33 441 442 443 444 NAND4_X1
X457 444 258 N107 445 AOI21_X1
X458 N58 251 253 N128 257 N50 446 AOI222_X1
X459 N132 254 256 N143 N150 258 447 AOI222_X1
X460 N33 N137 249 255 N159 448 AOI221_X1
X461 446 447 448 449 AND3_X1
X462 246 445 449 450 OAI21_X1
X463 273 450 299 N68 451 OAI211_X1
X464 438 439 440 451 N5121 OAI211_X1
X465 413 414 419 452 NAND3_X1
X466 272 329 209 224 453 AOI211_X1
X467 149 211 454 NOR2_X1
X468 162 454 455 XNOR2_X1
X469 313 322 455 456 AND3_X1
X470 455 322 313 457 AOI21_X1
X471 456 457 458 OR2_X1
X472 8 229 270 412 456 457 459 OAI33_X1
X473 459 453 452 412 458 460 AOI221_X1
X474 99 455 461 NOR2_X1
X475 N77 255 257 N68 462 AOI22_X1
X476 N128 249 254 N125 463 AOI22_X1
X477 N124 253 257 N150 464 AOI22_X1
X478 N33 N143 255 258 N137 465 AOI221_X1
X479 463 464 466 NAND2_X1
X480 466 256 N132 N159 251 467 AOI221_X1
X481 N107 249 253 N283 468 AOI22_X1
X482 3 N116 254 256 N97 469 AOI221_X1
X483 N58 251 258 N87 470 AOI22_X1
X484 462 469 470 471 AND3_X1
X485 N41 465 467 468 471 472 AOI221_X1
X486 247 472 N41 N50 473 AOI211_X1
X487 273 299 N50 474 OAI21_X1
X488 461 473 474 475 NOR3_X1
X489 460 475 476 NOR2_X1
X490 476 N5120 INV_X1
X491 437 476 477 NAND2_X1
X492 437 476 478 XNOR2_X1
X493 N4944 N5121 479 XNOR2_X1
X494 N4815 N5047 480 XOR2_X1
X495 369 N5078 481 XNOR2_X1
X496 480 481 482 XNOR2_X1
X497 479 482 483 XNOR2_X1
X498 478 483 N5361 XNOR2_X1
X499 N232 N58 N270 N116 484 AOI22_X1
X500 N226 N50 N87 N250 N257 N97 485 AOI222_X1
X501 N238 N68 N244 N77 N107 N264 486 AOI222_X1
X502 484 485 486 487 NAND3_X1
X503 N250 N264 N257 488 OAI21_X1
X504 2 30 231 488 31 N13 489 OAI33_X1
X505 489 487 31 N3195 AOI21_X1
X506 277 406 N3987 XOR2_X1
X507 19 N213 490 NAND2_X1
X508 20 478 490 491 MUX2_X1
X509 483 491 N5360 XNOR2_X1
X510 327 328 N4145 NAND2_X1
X511 N4815 N5045 N5047 N5078 492 OR4_X1
X512 N4944 N5121 477 492 N5192 OR4_X1
X513 N213 N5192 477 N343 N5231 OAI211_X1
V0 N4667 N4587 DC 0
V1 N4667 N4628 DC 0
V2 N4815 N4727 DC 0
V3 N4815 N4778 DC 0
V4 N4815 N4812 DC 0
V5 N4944 N4876 DC 0
V6 N4944 N4920 DC 0
V7 N4944 N4937 DC 0
V8 N4944 N4940 DC 0
V9 N5002 N4964 DC 0
V10 N5002 N4980 DC 0
V11 N5045 N4988 DC 0
V12 N5047 N4996 DC 0
V13 N5078 N5018 DC 0
V14 N5045 N5026 DC 0
V15 N5047 N5029 DC 0
V16 N5047 N5039 DC 0
V17 N5045 N5042 DC 0
V18 N5078 N5046 DC 0
V19 N5102 N5050 DC 0
V20 N33 N1849 DC 0
V21 N5121 N5058 DC 0
V22 N5078 N5070 DC 0
V23 N5120 N5080 DC 0
V24 N33 N1851 DC 0
V25 N5121 N5103 DC 0
V26 N33 N1853 DC 0
V27 N5121 N5111 DC 0
V28 N33 N1855 DC 0
V29 N5102 N5117 DC 0
V30 N33 N1857 DC 0
V31 N5120 N5139 DC 0
V32 N5121 N5151 DC 0
V33 N5121 N5154 DC 0
V34 N13 N1279 DC 0
V35 N33 N1859 DC 0
V36 N33 N1861 DC 0
V37 N33 N1863 DC 0
V38 N33 N1369 DC 0
V39 N1 N1334 DC 0
V40 N107 N1502 DC 0
V41 N45 N1737 DC 0
V42 N45 N1736 DC 0
V43 N1947 N1735 DC 0
V44 N107 N1499 DC 0
V45 N68 N1496 DC 0
V46 N68 N1493 DC 0
V47 N50 N1726 DC 0
V48 N20 N1352 DC 0
V49 N20 N1351 DC 0
V50 N20 N1345 DC 0
V51 N5360 N5356 DC 0
V52 N5360 N5357 DC 0
V53 N50 N655 DC 0
V54 N20 N1350 DC 0
V55 N58 N670 DC 0
V56 N20 N1349 DC 0
V57 N68 N683 DC 0
V58 N20 N1348 DC 0
V59 N68 N690 DC 0
V60 N77 N699 DC 0
V61 N77 N706 DC 0
V62 N87 N715 DC 0
V63 N97 N727 DC 0
V64 N107 N740 DC 0
V65 N116 N753 DC 0
V66 N1 N772 DC 0
V67 N13 N782 DC 0
V68 N20 N798 DC 0
V69 N33 N821 DC 0
V70 N45 N836 DC 0
V71 N58 N845 DC 0
V72 N68 N851 DC 0
V73 N87 N858 DC 0
V74 N97 N864 DC 0
V75 N20 N1347 DC 0
V76 N20 N1346 DC 0
V77 N1 N874 DC 0
V78 N68 N877 DC 0
V79 N107 N880 DC 0
V80 N190 N886 DC 0
V81 N116 N1946 DC 0
V82 N107 N1945 DC 0
V83 N97 N1944 DC 0
V84 N87 N1943 DC 0
V85 N77 N1942 DC 0
V86 N68 N1941 DC 0
V87 N179 N917 DC 0
V88 N58 N1939 DC 0
V89 N343 N923 DC 0
V90 N226 N926 DC 0
V91 N232 N929 DC 0
V92 N238 N932 DC 0
V93 N244 N935 DC 0
V94 N250 N938 DC 0
V95 N257 N941 DC 0
V96 N264 N944 DC 0
V97 N270 N947 DC 0
V98 N50 N950 DC 0
V99 N58 N953 DC 0
V100 N58 N956 DC 0
V101 N97 N959 DC 0
V102 N97 N962 DC 0
V103 N330 N965 DC 0

************************
* end of SPICE netlist *
************************

* Anti-Floating Pull-Downs (GMIN)
R_PD_0 N5121 0 100meg
R_PD_1 96 0 100meg
R_PD_2 177 0 100meg
R_PD_3 187 0 100meg
R_PD_4 413 0 100meg
R_PD_5 157 0 100meg
R_PD_6 N137 0 100meg
R_PD_7 443 0 100meg
R_PD_8 275 0 100meg
R_PD_9 117 0 100meg
R_PD_10 38 0 100meg
R_PD_11 468 0 100meg
R_PD_12 N116 0 100meg
R_PD_13 472 0 100meg
R_PD_14 398 0 100meg
R_PD_15 225 0 100meg
R_PD_16 259 0 100meg
R_PD_17 330 0 100meg
R_PD_18 109 0 100meg
R_PD_19 471 0 100meg
R_PD_20 363 0 100meg
R_PD_21 N200 0 100meg
R_PD_22 72 0 100meg
R_PD_23 N4145 0 100meg
R_PD_24 313 0 100meg
R_PD_25 N5361 0 100meg
R_PD_26 N244 0 100meg
R_PD_27 161 0 100meg
R_PD_28 304 0 100meg
R_PD_29 76 0 100meg
R_PD_30 211 0 100meg
R_PD_31 200 0 100meg
R_PD_32 229 0 100meg
R_PD_33 239 0 100meg
R_PD_34 485 0 100meg
R_PD_35 383 0 100meg
R_PD_36 N45 0 100meg
R_PD_37 354 0 100meg
R_PD_38 102 0 100meg
R_PD_39 52 0 100meg
R_PD_40 127 0 100meg
R_PD_41 321 0 100meg
R_PD_42 43 0 100meg
R_PD_43 242 0 100meg
R_PD_44 135 0 100meg
R_PD_45 222 0 100meg
R_PD_46 61 0 100meg
R_PD_47 324 0 100meg
R_PD_48 215 0 100meg
R_PD_49 N3833 0 100meg
R_PD_50 464 0 100meg
R_PD_51 48 0 100meg
R_PD_52 228 0 100meg
R_PD_53 350 0 100meg
R_PD_54 106 0 100meg
R_PD_55 58 0 100meg
R_PD_56 230 0 100meg
R_PD_57 260 0 100meg
R_PD_58 10 0 100meg
R_PD_59 N3195 0 100meg
R_PD_60 437 0 100meg
R_PD_61 56 0 100meg
R_PD_62 68 0 100meg
R_PD_63 208 0 100meg
R_PD_64 424 0 100meg
R_PD_65 37 0 100meg
R_PD_66 134 0 100meg
R_PD_67 406 0 100meg
R_PD_68 3 0 100meg
R_PD_69 20 0 100meg
R_PD_70 276 0 100meg
R_PD_71 N125 0 100meg
R_PD_72 404 0 100meg
R_PD_73 307 0 100meg
R_PD_74 N4667 0 100meg
R_PD_75 396 0 100meg
R_PD_76 416 0 100meg
R_PD_77 N20 0 100meg
R_PD_78 355 0 100meg
R_PD_79 214 0 100meg
R_PD_80 165 0 100meg
R_PD_81 271 0 100meg
R_PD_82 180 0 100meg
R_PD_83 N107 0 100meg
R_PD_84 142 0 100meg
R_PD_85 151 0 100meg
R_PD_86 364 0 100meg
R_PD_87 483 0 100meg
R_PD_88 302 0 100meg
R_PD_89 N97 0 100meg
R_PD_90 17 0 100meg
R_PD_91 N5002 0 100meg
R_PD_92 166 0 100meg
R_PD_93 36 0 100meg
R_PD_94 343 0 100meg
R_PD_95 N77 0 100meg
R_PD_96 138 0 100meg
R_PD_97 202 0 100meg
R_PD_98 467 0 100meg
R_PD_99 476 0 100meg
R_PD_100 322 0 100meg
R_PD_101 257 0 100meg
R_PD_102 261 0 100meg
R_PD_103 236 0 100meg
R_PD_104 325 0 100meg
R_PD_105 53 0 100meg
R_PD_106 59 0 100meg
R_PD_107 113 0 100meg
R_PD_108 310 0 100meg
R_PD_109 128 0 100meg
R_PD_110 369 0 100meg
R_PD_111 287 0 100meg
R_PD_112 318 0 100meg
R_PD_113 125 0 100meg
R_PD_114 365 0 100meg
R_PD_115 255 0 100meg
R_PD_116 92 0 100meg
R_PD_117 409 0 100meg
R_PD_118 22 0 100meg
R_PD_119 475 0 100meg
R_PD_120 N3987 0 100meg
R_PD_121 44 0 100meg
R_PD_122 71 0 100meg
R_PD_123 256 0 100meg
R_PD_124 262 0 100meg
R_PD_125 41 0 100meg
R_PD_126 N128 0 100meg
R_PD_127 209 0 100meg
R_PD_128 130 0 100meg
R_PD_129 152 0 100meg
R_PD_130 104 0 100meg
R_PD_131 492 0 100meg
R_PD_132 111 0 100meg
R_PD_133 237 0 100meg
R_PD_134 277 0 100meg
R_PD_135 N5120 0 100meg
R_PD_136 N1713 0 100meg
R_PD_137 243 0 100meg
R_PD_138 31 0 100meg
R_PD_139 445 0 100meg
R_PD_140 N330 0 100meg
R_PD_141 N283 0 100meg
R_PD_142 159 0 100meg
R_PD_143 389 0 100meg
R_PD_144 465 0 100meg
R_PD_145 27 0 100meg
R_PD_146 78 0 100meg
R_PD_147 323 0 100meg
R_PD_148 366 0 100meg
R_PD_149 13 0 100meg
R_PD_150 381 0 100meg
R_PD_151 N274 0 100meg
R_PD_152 N5231 0 100meg
R_PD_153 346 0 100meg
R_PD_154 178 0 100meg
R_PD_155 484 0 100meg
R_PD_156 162 0 100meg
R_PD_157 405 0 100meg
R_PD_158 N294 0 100meg
R_PD_159 300 0 100meg
R_PD_160 386 0 100meg
R_PD_161 253 0 100meg
R_PD_162 N5360 0 100meg
R_PD_163 21 0 100meg
R_PD_164 269 0 100meg
R_PD_165 382 0 100meg
R_PD_166 342 0 100meg
R_PD_167 169 0 100meg
R_PD_168 N232 0 100meg
R_PD_169 331 0 100meg
R_PD_170 357 0 100meg
R_PD_171 N223 0 100meg
R_PD_172 440 0 100meg
R_PD_173 452 0 100meg
R_PD_174 65 0 100meg
R_PD_175 N343 0 100meg
R_PD_176 N4815 0 100meg
R_PD_177 327 0 100meg
R_PD_178 N350 0 100meg
R_PD_179 87 0 100meg
R_PD_180 470 0 100meg
R_PD_181 280 0 100meg
R_PD_182 344 0 100meg
R_PD_183 477 0 100meg
R_PD_184 136 0 100meg
R_PD_185 N250 0 100meg
R_PD_186 466 0 100meg
R_PD_187 232 0 100meg
R_PD_188 244 0 100meg
R_PD_189 66 0 100meg
R_PD_190 51 0 100meg
R_PD_191 349 0 100meg
R_PD_192 415 0 100meg
R_PD_193 407 0 100meg
R_PD_194 26 0 100meg
R_PD_195 279 0 100meg
R_PD_196 N13 0 100meg
R_PD_197 339 0 100meg
R_PD_198 107 0 100meg
R_PD_199 1 0 100meg
R_PD_200 100 0 100meg
R_PD_201 301 0 100meg
R_PD_202 235 0 100meg
R_PD_203 116 0 100meg
R_PD_204 267 0 100meg
R_PD_205 372 0 100meg
R_PD_206 425 0 100meg
R_PD_207 420 0 100meg
R_PD_208 293 0 100meg
R_PD_209 N329 0 100meg
R_PD_210 144 0 100meg
R_PD_211 89 0 100meg
R_PD_212 153 0 100meg
R_PD_213 332 0 100meg
R_PD_214 121 0 100meg
R_PD_215 149 0 100meg
R_PD_216 97 0 100meg
R_PD_217 15 0 100meg
R_PD_218 314 0 100meg
R_PD_219 238 0 100meg
R_PD_220 4 0 100meg
R_PD_221 N1 0 100meg
R_PD_222 455 0 100meg
R_PD_223 360 0 100meg
R_PD_224 375 0 100meg
R_PD_225 N179 0 100meg
R_PD_226 433 0 100meg
R_PD_227 201 0 100meg
R_PD_228 7 0 100meg
R_PD_229 231 0 100meg
R_PD_230 246 0 100meg
R_PD_231 419 0 100meg
R_PD_232 442 0 100meg
R_PD_233 207 0 100meg
R_PD_234 150 0 100meg
R_PD_235 370 0 100meg
R_PD_236 N5078 0 100meg
R_PD_237 408 0 100meg
R_PD_238 337 0 100meg
R_PD_239 N124 0 100meg
R_PD_240 254 0 100meg
R_PD_241 473 0 100meg
R_PD_242 306 0 100meg
R_PD_243 417 0 100meg
R_PD_244 316 0 100meg
R_PD_245 263 0 100meg
R_PD_246 N5192 0 100meg
R_PD_247 192 0 100meg
R_PD_248 309 0 100meg
R_PD_249 395 0 100meg
R_PD_250 399 0 100meg
R_PD_251 298 0 100meg
R_PD_252 34 0 100meg
R_PD_253 219 0 100meg
R_PD_254 393 0 100meg
R_PD_255 367 0 100meg
R_PD_256 N264 0 100meg
R_PD_257 241 0 100meg
R_PD_258 290 0 100meg
R_PD_259 426 0 100meg
R_PD_260 299 0 100meg
R_PD_261 245 0 100meg
R_PD_262 172 0 100meg
R_PD_263 N150 0 100meg
R_PD_264 223 0 100meg
R_PD_265 190 0 100meg
R_PD_266 461 0 100meg
R_PD_267 252 0 100meg
R_PD_268 438 0 100meg
R_PD_269 88 0 100meg
R_PD_270 93 0 100meg
R_PD_271 335 0 100meg
R_PD_272 490 0 100meg
R_PD_273 N68 0 100meg
R_PD_274 249 0 100meg
R_PD_275 251 0 100meg
R_PD_276 32 0 100meg
R_PD_277 371 0 100meg
R_PD_278 182 0 100meg
R_PD_279 14 0 100meg
R_PD_280 446 0 100meg
R_PD_281 175 0 100meg
R_PD_282 N326 0 100meg
R_PD_283 84 0 100meg
R_PD_284 274 0 100meg
R_PD_285 486 0 100meg
R_PD_286 185 0 100meg
R_PD_287 489 0 100meg
R_PD_288 422 0 100meg
R_PD_289 488 0 100meg
R_PD_290 430 0 100meg
R_PD_291 191 0 100meg
R_PD_292 296 0 100meg
R_PD_293 454 0 100meg
R_PD_294 400 0 100meg
R_PD_295 176 0 100meg
R_PD_296 295 0 100meg
R_PD_297 194 0 100meg
R_PD_298 N5047 0 100meg
R_PD_299 233 0 100meg
R_PD_300 358 0 100meg
R_PD_301 411 0 100meg
R_PD_302 317 0 100meg
R_PD_303 234 0 100meg
R_PD_304 474 0 100meg
R_PD_305 148 0 100meg
R_PD_306 428 0 100meg
R_PD_307 390 0 100meg
R_PD_308 431 0 100meg
R_PD_309 60 0 100meg
R_PD_310 N317 0 100meg
R_PD_311 266 0 100meg
R_PD_312 55 0 100meg
R_PD_313 39 0 100meg
R_PD_314 18 0 100meg
R_PD_315 179 0 100meg
R_PD_316 126 0 100meg
R_PD_317 158 0 100meg
R_PD_318 401 0 100meg
R_PD_319 462 0 100meg
R_PD_320 137 0 100meg
R_PD_321 N143 0 100meg
R_PD_322 23 0 100meg
R_PD_323 30 0 100meg
R_PD_324 221 0 100meg
R_PD_325 167 0 100meg
R_PD_326 132 0 100meg
R_PD_327 N87 0 100meg
R_PD_328 29 0 100meg
R_PD_329 351 0 100meg
R_PD_330 491 0 100meg
R_PD_331 90 0 100meg
R_PD_332 294 0 100meg
R_PD_333 347 0 100meg
R_PD_334 6 0 100meg
R_PD_335 216 0 100meg
R_PD_336 402 0 100meg
R_PD_337 146 0 100meg
R_PD_338 64 0 100meg
R_PD_339 73 0 100meg
R_PD_340 164 0 100meg
R_PD_341 384 0 100meg
R_PD_342 374 0 100meg
R_PD_343 441 0 100meg
R_PD_344 432 0 100meg
R_PD_345 156 0 100meg
R_PD_346 264 0 100meg
R_PD_347 131 0 100meg
R_PD_348 449 0 100meg
R_PD_349 N41 0 100meg
R_PD_350 115 0 100meg
R_PD_351 160 0 100meg
R_PD_352 397 0 100meg
R_PD_353 450 0 100meg
R_PD_354 186 0 100meg
R_PD_355 147 0 100meg
R_PD_356 74 0 100meg
R_PD_357 421 0 100meg
R_PD_358 247 0 100meg
R_PD_359 46 0 100meg
R_PD_360 403 0 100meg
R_PD_361 198 0 100meg
R_PD_362 N238 0 100meg
R_PD_363 N270 0 100meg
R_PD_364 170 0 100meg
R_PD_365 173 0 100meg
R_PD_366 288 0 100meg
R_PD_367 124 0 100meg
R_PD_368 240 0 100meg
R_PD_369 8 0 100meg
R_PD_370 227 0 100meg
R_PD_371 265 0 100meg
R_PD_372 99 0 100meg
R_PD_373 199 0 100meg
R_PD_374 54 0 100meg
R_PD_375 108 0 100meg
R_PD_376 217 0 100meg
R_PD_377 112 0 100meg
R_PD_378 283 0 100meg
R_PD_379 86 0 100meg
R_PD_380 28 0 100meg
R_PD_381 120 0 100meg
R_PD_382 226 0 100meg
R_PD_383 118 0 100meg
R_PD_384 212 0 100meg
R_PD_385 338 0 100meg
R_PD_386 303 0 100meg
R_PD_387 33 0 100meg
R_PD_388 458 0 100meg
R_PD_389 98 0 100meg
R_PD_390 391 0 100meg
R_PD_391 297 0 100meg
R_PD_392 N5102 0 100meg
R_PD_393 392 0 100meg
R_PD_394 94 0 100meg
R_PD_395 171 0 100meg
R_PD_396 N5045 0 100meg
R_PD_397 155 0 100meg
R_PD_398 348 0 100meg
R_PD_399 379 0 100meg
R_PD_400 273 0 100meg
R_PD_401 189 0 100meg
R_PD_402 376 0 100meg
R_PD_403 434 0 100meg
R_PD_404 139 0 100meg
R_PD_405 80 0 100meg
R_PD_406 286 0 100meg
R_PD_407 292 0 100meg
R_PD_408 45 0 100meg
R_PD_409 248 0 100meg
R_PD_410 213 0 100meg
R_PD_411 478 0 100meg
R_PD_412 49 0 100meg
R_PD_413 62 0 100meg
R_PD_414 122 0 100meg
R_PD_415 N50 0 100meg
R_PD_416 205 0 100meg
R_PD_417 220 0 100meg
R_PD_418 469 0 100meg
R_PD_419 319 0 100meg
R_PD_420 410 0 100meg
R_PD_421 N159 0 100meg
R_PD_422 203 0 100meg
R_PD_423 143 0 100meg
R_PD_424 67 0 100meg
R_PD_425 278 0 100meg
R_PD_426 312 0 100meg
R_PD_427 435 0 100meg
R_PD_428 272 0 100meg
R_PD_429 N311 0 100meg
R_PD_430 281 0 100meg
R_PD_431 291 0 100meg
R_PD_432 340 0 100meg
R_PD_433 328 0 100meg
R_PD_434 5 0 100meg
R_PD_435 482 0 100meg
R_PD_436 101 0 100meg
R_PD_437 174 0 100meg
R_PD_438 487 0 100meg
R_PD_439 N169 0 100meg
R_PD_440 258 0 100meg
R_PD_441 N322 0 100meg
R_PD_442 69 0 100meg
R_PD_443 50 0 100meg
R_PD_444 184 0 100meg
R_PD_445 110 0 100meg
R_PD_446 N222 0 100meg
R_PD_447 436 0 100meg
R_PD_448 119 0 100meg
R_PD_449 N190 0 100meg
R_PD_450 181 0 100meg
R_PD_451 24 0 100meg
R_PD_452 57 0 100meg
R_PD_453 9 0 100meg
R_PD_454 N33 0 100meg
R_PD_455 12 0 100meg
R_PD_456 377 0 100meg
R_PD_457 459 0 100meg
R_PD_458 140 0 100meg
R_PD_459 N4944 0 100meg
R_PD_460 103 0 100meg
R_PD_461 451 0 100meg
R_PD_462 40 0 100meg
R_PD_463 195 0 100meg
R_PD_464 N349 0 100meg
R_PD_465 456 0 100meg
R_PD_466 285 0 100meg
R_PD_467 N213 0 100meg
R_PD_468 83 0 100meg
R_PD_469 418 0 100meg
R_PD_470 210 0 100meg
R_PD_471 447 0 100meg
R_PD_472 2 0 100meg
R_PD_473 308 0 100meg
R_PD_474 429 0 100meg
R_PD_475 341 0 100meg
R_PD_476 453 0 100meg
R_PD_477 75 0 100meg
R_PD_478 394 0 100meg
R_PD_479 141 0 100meg
R_PD_480 460 0 100meg
R_PD_481 463 0 100meg
R_PD_482 N257 0 100meg
R_PD_483 356 0 100meg
R_PD_484 82 0 100meg
R_PD_485 105 0 100meg
R_PD_486 168 0 100meg
R_PD_487 362 0 100meg
R_PD_488 457 0 100meg
R_PD_489 85 0 100meg
R_PD_490 481 0 100meg
R_PD_491 311 0 100meg
R_PD_492 79 0 100meg
R_PD_493 378 0 100meg
R_PD_494 479 0 100meg
R_PD_495 154 0 100meg
R_PD_496 204 0 100meg
R_PD_497 480 0 100meg
R_PD_498 224 0 100meg
R_PD_499 16 0 100meg
R_PD_500 70 0 100meg
R_PD_501 163 0 100meg
R_PD_502 193 0 100meg
R_PD_503 N1947 0 100meg
R_PD_504 77 0 100meg
R_PD_505 183 0 100meg
R_PD_506 N303 0 100meg
R_PD_507 368 0 100meg
R_PD_508 35 0 100meg
R_PD_509 188 0 100meg
R_PD_510 N132 0 100meg
R_PD_511 114 0 100meg
R_PD_512 145 0 100meg
R_PD_513 206 0 100meg
R_PD_514 218 0 100meg
R_PD_515 387 0 100meg
R_PD_516 385 0 100meg
R_PD_517 197 0 100meg
R_PD_518 N226 0 100meg
R_PD_519 47 0 100meg
R_PD_520 326 0 100meg
R_PD_521 N4589 0 100meg
R_PD_522 63 0 100meg
R_PD_523 81 0 100meg
R_PD_524 315 0 100meg
R_PD_525 42 0 100meg
R_PD_526 336 0 100meg
R_PD_527 333 0 100meg
R_PD_528 123 0 100meg
R_PD_529 25 0 100meg
R_PD_530 359 0 100meg
R_PD_531 439 0 100meg
R_PD_532 427 0 100meg
R_PD_533 305 0 100meg
R_PD_534 284 0 100meg
R_PD_535 289 0 100meg
R_PD_536 N58 0 100meg
R_PD_537 334 0 100meg
R_PD_538 196 0 100meg
R_PD_539 268 0 100meg
R_PD_540 270 0 100meg
R_PD_541 373 0 100meg
R_PD_542 19 0 100meg
R_PD_543 250 0 100meg
R_PD_544 N4028 0 100meg
R_PD_545 361 0 100meg
R_PD_546 414 0 100meg
R_PD_547 444 0 100meg
R_PD_548 448 0 100meg
R_PD_549 129 0 100meg
R_PD_550 95 0 100meg
R_PD_551 329 0 100meg
R_PD_552 352 0 100meg
R_PD_553 353 0 100meg
R_PD_554 412 0 100meg
R_PD_555 345 0 100meg
R_PD_556 320 0 100meg
R_PD_557 91 0 100meg
R_PD_558 380 0 100meg
R_PD_559 282 0 100meg
R_PD_560 423 0 100meg
R_PD_561 388 0 100meg
R_PD_562 11 0 100meg
R_PD_563 133 0 100meg

* Transient Simulation Directive
.TRAN 100p 10n
