* Nangila SPICE Auto-Synthesized Netlist
.SUBCKT INV_X1 A Z
M1 Z A 0 0 NMOS W=0.2u L=0.05u
M2 Z A 1 1 PMOS W=0.4u L=0.05u
.ENDS

.SUBCKT NAND2_X1 A1 A2 Z
M1 Z A1 1 1 PMOS W=0.4u L=0.05u
M2 Z A2 1 1 PMOS W=0.4u L=0.05u
M3 Z A1 int 0 NMOS W=0.2u L=0.05u
M4 int A2 0 0 NMOS W=0.2u L=0.05u
.ENDS

.SUBCKT AND2_X1 A1 A2 Z
X1 A1 A2 Z_bar NAND2_X1
X2 Z_bar Z INV_X1
.ENDS

.SUBCKT NOR2_X1 A1 A2 Z
M1 int1 A1 1 1 PMOS W=0.4u L=0.05u
M2 Z A2 int1 1 PMOS W=0.4u L=0.05u
M3 Z A1 0 0 NMOS W=0.2u L=0.05u
M4 Z A2 0 0 NMOS W=0.2u L=0.05u
.ENDS

.SUBCKT OR2_X1 A1 A2 Z
X1 A1 A2 Z_bar NOR2_X1
X2 Z_bar Z INV_X1
.ENDS

.SUBCKT XOR2_X1 A1 A2 Z
X1 A1 A2 int1 AND2_X1
X2 A1 A2 int2 NOR2_X1
X3 int1 int2 int3 NOR2_X1
X4 int3 Z INV_X1
.ENDS

.SUBCKT XNOR2_X1 A B Z
X1 A B Z_int XOR2_X1
X2 Z_int Z INV_X1
.ENDS

.SUBCKT BUF_X1 A Z
X1 A Z_bar INV_X1
X2 Z_bar Z INV_X1
.ENDS

.SUBCKT OAI21_X1 A B C Z
X1 A B C Z_bar AOI21_X1
X2 Z_bar Z INV_X1
.ENDS

.SUBCKT AOI21_X1 A B C Z
M1 Z A int1 1 PMOS W=0.4u L=0.05u
M2 int1 B 1 1 PMOS W=0.4u L=0.05u
M3 Z C 1 1 PMOS W=0.4u L=0.05u
M4 Z A 0 0 NMOS W=0.2u L=0.05u
M5 Z B 0 0 NMOS W=0.2u L=0.05u
M6 Z C 0 0 NMOS W=0.2u L=0.05u
.ENDS

.SUBCKT NAND3_X1 A1 A2 A3 Z
X1 A1 A2 int1 AND2_X1
X2 int1 A3 Z NAND2_X1
.ENDS

.SUBCKT AND3_X1 A1 A2 A3 Z
X1 A1 A2 A3 Z_bar NAND3_X1
X2 Z_bar Z INV_X1
.ENDS

.SUBCKT NOR3_X1 A1 A2 A3 Z
X1 A1 A2 int1 OR2_X1
X2 int1 A3 Z NOR2_X1
.ENDS

.SUBCKT OR3_X1 A1 A2 A3 Z
X1 A1 A2 A3 Z_bar NOR3_X1
X2 Z_bar Z INV_X1
.ENDS

.SUBCKT NAND4_X1 A1 A2 A3 A4 Z
X1 A1 A2 A3 int1 AND3_X1
X2 int1 A4 Z NAND2_X1
.ENDS

.SUBCKT AND4_X1 A1 A2 A3 A4 Z
X1 A1 A2 A3 A4 Z_bar NAND4_X1
X2 Z_bar Z INV_X1
.ENDS

.SUBCKT NOR4_X1 A1 A2 A3 A4 Z
X1 A1 A2 A3 int1 OR3_X1
X2 int1 A4 Z NOR2_X1
.ENDS

.SUBCKT OR4_X1 A1 A2 A3 A4 Z
X1 A1 A2 A3 A4 Z_bar NOR4_X1
X2 Z_bar Z INV_X1
.ENDS

.SUBCKT AOI22_X1 A B C D Z
X1 A B int1 AND2_X1
X2 C D int2 AND2_X1
X3 int1 int2 Z NOR2_X1
.ENDS

.SUBCKT OAI22_X1 A B C D Z
X1 A B int1 OR2_X1
X2 C D int2 OR2_X1
X3 int1 int2 Z NAND2_X1
.ENDS

.SUBCKT AOI211_X1 A B C D Z
X1 A B int1 AND2_X1
X2 int1 C D Z NOR3_X1
.ENDS

.SUBCKT OAI211_X1 A B C D Z
X1 A B int1 OR2_X1
X2 int1 C D Z NAND3_X1
.ENDS

.SUBCKT OAI33_X1 A B C D E F Z
X1 A B C int1 OR3_X1
X2 D E F int2 OR3_X1
X3 int1 int2 Z NAND2_X1
.ENDS

.SUBCKT AOI33_X1 A B C D E F Z
X1 A B C int1 AND3_X1
X2 D E F int2 AND3_X1
X3 int1 int2 Z NOR2_X1
.ENDS

.SUBCKT MUX2_X1 A B S Z
X1 S S_bar INV_X1
X2 A S_bar int1 AND2_X1
X3 B S int2 AND2_X1
X4 int1 int2 Z OR2_X1
.ENDS

.SUBCKT DFF_X1 D C Q QN
X1 D Q_int INV_X1
X2 Q_int Q INV_X1
X3 Q_int QN INV_X1
.ENDS

.SUBCKT DFFR_X1 D C RN Q QN
X1 D Q_int INV_X1
X2 Q_int Q INV_X1
X3 Q_int QN INV_X1
.ENDS

.SUBCKT DFFS_X1 C D Q QN SN
X1 D Q_int INV_X1
X2 Q_int Q INV_X1
X3 Q_int QN INV_X1
.ENDS

.SUBCKT DFFRS_X1 C D Q QN RN SN
X1 D Q_int INV_X1
X2 Q_int Q INV_X1
X3 Q_int QN INV_X1
.ENDS

* Provide VDD power source explicitly
Vvdd 1 0 1.8

* Auto-extracted Inputs:
V_CK CK 0 1.8
V_D D 0 0.0
V_CK CK 0 1.8
V_G1 G1 0 0.0
V_G2 G2 0 1.8
V_G3 G3 0 0.0
V_G4 G4 0 1.8
V_G5 G5 0 0.0
V_G6 G6 0 1.8
V_G8 G8 0 0.0
V_G9 G9 0 1.8
V_G10 G10 0 0.0
V_G11 G11 0 1.8
V_G12 G12 0 0.0
V_G13 G13 0 1.8
V_G14 G14 0 0.0
V_G15 G15 0 1.8
V_G16 G16 0 0.0
V_G17 G17 0 1.8
V_G18 G18 0 0.0
V_G19 G19 0 1.8
V_G20 G20 0 0.0
V_G21 G21 0 1.8
V_G22 G22 0 0.0
V_G23 G23 0 1.8
V_G24 G24 0 0.0
V_G25 G25 0 1.8
V_G26 G26 0 0.0
V_G27 G27 0 1.8
V_G28 G28 0 0.0
V_G29 G29 0 1.8
V_G30 G30 0 0.0
V_G31 G31 0 1.8
V_G32 G32 0 0.0
V_G33 G33 0 1.8
V_G34 G34 0 0.0
V_G35 G35 0 1.8
V_G36 G36 0 0.0

* Yosys Generated Netlist:
* SPICE netlist generated by Yosys 0.62 (git sha1 7326bb7d6641500ecb285c291a54a662cb1e76cf, clang++ 17.0.0 -fPIC -O3)

.SUBCKT dff CK Q D
X0 CK D Q 1 DFF_X1
.ENDS dff

X0 G11 1 INV_X1
X1 G10 2 INV_X1
X2 G9 3 INV_X1
X3 G215 4 INV_X1
X4 G211 5 INV_X1
X5 G213 6 INV_X1
X6 G65 7 INV_X1
X7 G67 8 INV_X1
X8 G2 9 INV_X1
X9 G3 10 INV_X1
X10 G4 11 INV_X1
X11 G217 G18 11 G107 AND3_X1
X12 G219 G19 11 G83 AND3_X1
X13 G221 G20 11 G84 AND3_X1
X14 G223 G21 11 G85 AND3_X1
X15 G11 G12 G13 G28 G92 AND4_X1
X16 G13 2 12 NOR2_X1
X17 G13 2 3 G3 13 NOR4_X1
X18 G13 2 3 G3 14 OR4_X1
X19 G11 G3 15 OR2_X1
X20 G25 8 15 16 AND3_X1
X21 G25 8 15 17 NAND3_X1
X22 13 17 18 NOR2_X1
X23 18 G89BF INV_X1
X24 G109 18 G122 AND2_X1
X25 G3 14 16 19 AOI21_X1
X26 10 13 17 20 OAI21_X1
X27 4 19 21 NOR2_X1
X28 G215 20 22 NAND2_X1
X29 G2 22 G132 NOR2_X1
X30 G66 9 23 NAND2_X1
X31 23 20 G215 24 AOI21_X1
X32 G66 9 19 4 25 OAI211_X1
X33 G13 G10 26 NOR2_X1
X34 G9 10 26 27 NAND3_X1
X35 G24 15 27 28 AND3_X1
X36 G24 15 27 29 NAND3_X1
X37 24 29 30 NOR2_X1
X38 30 G88BF INV_X1
X39 G3 25 28 31 AOI21_X1
X40 10 24 29 32 OAI21_X1
X41 G213 32 33 NAND2_X1
X42 33 G158 INV_X1
X43 G2 21 33 G131 NOR3_X1
X44 21 G158 34 NOR2_X1
X45 G9 G3 35 NOR2_X1
X46 12 35 36 NAND2_X1
X47 G23 7 15 36 37 AND4_X1
X48 37 G87BF INV_X1
X49 5 10 G87BF 38 AOI21_X1
X50 G211 G3 37 39 OAI21_X1
X51 G2 21 G158 39 G130 NOR4_X1
X52 21 38 32 G213 40 AOI211_X1
X53 22 39 31 6 41 OAI211_X1
X54 G64 9 42 AND2_X1
X55 26 35 43 NAND2_X1
X56 G22 15 43 44 NAND3_X1
X57 44 42 40 45 AOI21_X1
X58 45 G86BF INV_X1
X59 G209 G3 45 46 OAI21_X1
X60 46 G150 INV_X1
X61 G2 41 46 G129 NOR3_X1
X62 G121 45 47 AND2_X1
X63 47 48 INV_X1
X64 G119 11 49 AND2_X1
X65 G113 30 50 NAND2_X1
X66 G111 11 51 AND2_X1
X67 G111 11 52 NAND2_X1
X68 50 52 53 NOR2_X1
X69 G115 11 54 AND2_X1
X70 G115 11 55 NAND2_X1
X71 G117 37 56 NAND2_X1
X72 55 56 57 NOR2_X1
X73 1 G122 57 58 NAND3_X1
X74 G13 G10 G9 50 52 58 59 OAI33_X1
X75 47 49 59 60 NAND3_X1
X76 G9 26 53 61 NAND3_X1
X77 G12 G26 62 NAND2_X1
X78 G122 57 3 63 MUX2_X1
X79 62 63 12 64 AOI21_X1
X80 60 61 64 G90 AND3_X1
X81 40 47 49 65 NAND3_X1
X82 G8 9 G150 66 AOI21_X1
X83 66 65 46 G125 AOI21_X1
X84 G5 9 67 NOR2_X1
X85 G5 34 46 57 68 NAND4_X1
X86 68 67 39 G126 OAI21_X1
X87 39 46 69 NAND2_X1
X88 22 39 46 53 70 NAND4_X1
X89 G6 9 G158 71 AOI21_X1
X90 71 70 33 G127 AOI21_X1
X91 G1 G122 33 72 NAND3_X1
X92 21 9 G1 73 OAI21_X1
X93 73 72 69 G128 OAI21_X1
X94 G35 51 G100BF NAND2_X1
X95 G33 54 G98BF NAND2_X1
X96 G31 49 G96BF NAND2_X1
X97 G36 G122 G101BF NAND2_X1
X98 G17 21 G106BF NAND2_X1
X99 G117 G32 37 G97BF NAND3_X1
X100 G15 38 G104BF NAND2_X1
X101 54 56 G140 NAND2_X1
X102 56 55 37 G139 OAI21_X1
X103 G113 G34 30 G99BF NAND3_X1
X104 G16 G158 G105BF NAND2_X1
X105 50 51 G138 NAND2_X1
X106 50 52 30 G133 OAI21_X1
X107 G30 47 G95BF NAND2_X1
X108 G14 G150 G103BF NAND2_X1
X109 48 49 G142 NAND2_X1
X110 G86BF 49 74 NAND2_X1
X111 48 74 G141 NAND2_X1
X112 CK G64 G150 dff
X113 CK G65 G130 dff
X114 CK G121 G142 dff
X115 CK G209 G125 dff
X116 CK G211 G126 dff
X117 CK G213 G127 dff
X118 CK G215 G128 dff
X119 CK G217 G129 dff
X120 CK G219 G130 dff
X121 CK G221 G131 dff
X122 CK G223 G132 dff
X123 CK G66 G158 dff
X124 CK G67 G132 dff
X125 CK G109 G122 dff
X126 CK G111 G133 dff
X127 CK G113 G138 dff
X128 CK G115 G139 dff
X129 CK G117 G140 dff
X130 CK G119 G141 dff
V0 G130 G262 DC 0
V1 G122 G293 DC 0
V2 G122 G294 DC 0
V3 G150 G300 DC 0
V4 G150 G301 DC 0
V5 G158 G306 DC 0
V6 G158 G307 DC 0
V7 G132 G250 DC 0
V8 G1 G352 DC 0
V9 G86BF G354 DC 0
V10 G87BF G356 DC 0
V11 G88BF G358 DC 0
V12 G89BF G359 DC 0
V13 G4 G360 DC 0
V14 G5 G361 DC 0
V15 G6 G362 DC 0
V16 G8 G363 DC 0
V17 G9 G364 DC 0
V18 G10 G367 DC 0
V19 G132 G229 DC 0
V20 G150 G380 DC 0
V21 G122 G383 DC 0
V22 G11 G386 DC 0
V23 G12 G388 DC 0
V24 G13 G389 DC 0
V25 G158 G394 DC 0
V26 G109 G68 DC 0
V27 G111 G69 DC 0
V28 G113 G70 DC 0
V29 G115 G71 DC 0
V30 G117 G72 DC 0
V31 G119 G73 DC 0
V32 G121 G74 DC 0
V33 G209 G75 DC 0
V34 G211 G76 DC 0
V35 G213 G77 DC 0
V36 G215 G78 DC 0
V37 G217 G79 DC 0
V38 G219 G80 DC 0
V39 G221 G81 DC 0
V40 G223 G82 DC 0
V41 G27 G91 DC 0
V42 G29 G94 DC 0
V43 G87BF II335 DC 0
V44 G89BF II338 DC 0
V45 G87BF II341 DC 0
V46 G140 II373 DC 0
V47 G125 G271 DC 0
V48 G138 II440 DC 0
V49 G126 G272 DC 0
V50 G88BF II449 DC 0
V51 G88BF II452 DC 0
V52 G127 G273 DC 0
V53 G128 G274 DC 0
V54 G129 G275 DC 0
V55 G130 G276 DC 0
V56 G142 II511 DC 0
V57 G131 G277 DC 0
V58 G86BF II524 DC 0
V59 G86BF II527 DC 0
V60 G132 G278 DC 0
V61 G122 IIII208 DC 0
V62 G122 G146 DC 0
V63 G133 IIII285 DC 0
V64 G138 IIII320 DC 0
V65 G139 IIII327 DC 0
V66 G140 IIII334 DC 0
V67 G141 IIII341 DC 0
V68 G142 IIII348 DC 0
V69 G86BF IIII398 DC 0
V70 G87BF IIII406 DC 0
V71 G88BF IIII414 DC 0
V72 G89BF IIII422 DC 0
V73 G122 IIII476 DC 0

************************
* end of SPICE netlist *
************************

* Anti-Floating Pull-Downs (GMIN)
R_PD_0 G67 0 100meg
R_PD_1 G104BF 0 100meg
R_PD_2 G92 0 100meg
R_PD_3 G31 0 100meg
R_PD_4 G117 0 100meg
R_PD_5 38 0 100meg
R_PD_6 G223 0 100meg
R_PD_7 G115 0 100meg
R_PD_8 21 0 100meg
R_PD_9 69 0 100meg
R_PD_10 50 0 100meg
R_PD_11 G32 0 100meg
R_PD_12 G140 0 100meg
R_PD_13 G88BF 0 100meg
R_PD_14 60 0 100meg
R_PD_15 65 0 100meg
R_PD_16 72 0 100meg
R_PD_17 24 0 100meg
R_PD_18 G25 0 100meg
R_PD_19 55 0 100meg
R_PD_20 57 0 100meg
R_PD_21 G96BF 0 100meg
R_PD_22 9 0 100meg
R_PD_23 G30 0 100meg
R_PD_24 G95BF 0 100meg
R_PD_25 39 0 100meg
R_PD_26 12 0 100meg
R_PD_27 G20 0 100meg
R_PD_28 18 0 100meg
R_PD_29 G15 0 100meg
R_PD_30 G90 0 100meg
R_PD_31 D 0 100meg
R_PD_32 G97BF 0 100meg
R_PD_33 G3 0 100meg
R_PD_34 23 0 100meg
R_PD_35 30 0 100meg
R_PD_36 66 0 100meg
R_PD_37 40 0 100meg
R_PD_38 G126 0 100meg
R_PD_39 G17 0 100meg
R_PD_40 G121 0 100meg
R_PD_41 51 0 100meg
R_PD_42 29 0 100meg
R_PD_43 52 0 100meg
R_PD_44 43 0 100meg
R_PD_45 26 0 100meg
R_PD_46 G8 0 100meg
R_PD_47 6 0 100meg
R_PD_48 G83 0 100meg
R_PD_49 G11 0 100meg
R_PD_50 G109 0 100meg
R_PD_51 G107 0 100meg
R_PD_52 1 0 100meg
R_PD_53 64 0 100meg
R_PD_54 G28 0 100meg
R_PD_55 G87BF 0 100meg
R_PD_56 61 0 100meg
R_PD_57 2 0 100meg
R_PD_58 73 0 100meg
R_PD_59 48 0 100meg
R_PD_60 G213 0 100meg
R_PD_61 G84 0 100meg
R_PD_62 G66 0 100meg
R_PD_63 58 0 100meg
R_PD_64 G4 0 100meg
R_PD_65 10 0 100meg
R_PD_66 G132 0 100meg
R_PD_67 G129 0 100meg
R_PD_68 G36 0 100meg
R_PD_69 G86BF 0 100meg
R_PD_70 G150 0 100meg
R_PD_71 G33 0 100meg
R_PD_72 56 0 100meg
R_PD_73 G99BF 0 100meg
R_PD_74 68 0 100meg
R_PD_75 74 0 100meg
R_PD_76 15 0 100meg
R_PD_77 46 0 100meg
R_PD_78 37 0 100meg
R_PD_79 4 0 100meg
R_PD_80 3 0 100meg
R_PD_81 20 0 100meg
R_PD_82 G19 0 100meg
R_PD_83 G85 0 100meg
R_PD_84 G133 0 100meg
R_PD_85 7 0 100meg
R_PD_86 8 0 100meg
R_PD_87 16 0 100meg
R_PD_88 G9 0 100meg
R_PD_89 70 0 100meg
R_PD_90 G131 0 100meg
R_PD_91 G128 0 100meg
R_PD_92 G13 0 100meg
R_PD_93 G105BF 0 100meg
R_PD_94 G221 0 100meg
R_PD_95 G219 0 100meg
R_PD_96 G18 0 100meg
R_PD_97 G100BF 0 100meg
R_PD_98 G215 0 100meg
R_PD_99 54 0 100meg
R_PD_100 35 0 100meg
R_PD_101 G119 0 100meg
R_PD_102 G89BF 0 100meg
R_PD_103 G6 0 100meg
R_PD_104 G2 0 100meg
R_PD_105 G21 0 100meg
R_PD_106 17 0 100meg
R_PD_107 G14 0 100meg
R_PD_108 28 0 100meg
R_PD_109 G1 0 100meg
R_PD_110 CK 0 100meg
R_PD_111 34 0 100meg
R_PD_112 36 0 100meg
R_PD_113 G122 0 100meg
R_PD_114 G34 0 100meg
R_PD_115 G101BF 0 100meg
R_PD_116 33 0 100meg
R_PD_117 G141 0 100meg
R_PD_118 G139 0 100meg
R_PD_119 G158 0 100meg
R_PD_120 G10 0 100meg
R_PD_121 53 0 100meg
R_PD_122 59 0 100meg
R_PD_123 G125 0 100meg
R_PD_124 G103BF 0 100meg
R_PD_125 G130 0 100meg
R_PD_126 47 0 100meg
R_PD_127 63 0 100meg
R_PD_128 42 0 100meg
R_PD_129 G64 0 100meg
R_PD_130 G98BF 0 100meg
R_PD_131 G12 0 100meg
R_PD_132 G209 0 100meg
R_PD_133 22 0 100meg
R_PD_134 G23 0 100meg
R_PD_135 25 0 100meg
R_PD_136 44 0 100meg
R_PD_137 45 0 100meg
R_PD_138 71 0 100meg
R_PD_139 G65 0 100meg
R_PD_140 32 0 100meg
R_PD_141 41 0 100meg
R_PD_142 G26 0 100meg
R_PD_143 14 0 100meg
R_PD_144 49 0 100meg
R_PD_145 62 0 100meg
R_PD_146 19 0 100meg
R_PD_147 G5 0 100meg
R_PD_148 G217 0 100meg
R_PD_149 G106BF 0 100meg
R_PD_150 G16 0 100meg
R_PD_151 31 0 100meg
R_PD_152 Q 0 100meg
R_PD_153 G35 0 100meg
R_PD_154 27 0 100meg
R_PD_155 G142 0 100meg
R_PD_156 G138 0 100meg
R_PD_157 67 0 100meg
R_PD_158 G111 0 100meg
R_PD_159 G22 0 100meg
R_PD_160 G24 0 100meg
R_PD_161 G211 0 100meg
R_PD_162 13 0 100meg
R_PD_163 G113 0 100meg
R_PD_164 G127 0 100meg
R_PD_165 11 0 100meg
R_PD_166 5 0 100meg

* Transient Simulation Directive
.TRAN 100p 10n
