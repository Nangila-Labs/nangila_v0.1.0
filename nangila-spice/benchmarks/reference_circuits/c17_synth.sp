* SPICE netlist generated by Yosys 0.62 (git sha1 7326bb7d6641500ecb285c291a54a662cb1e76cf, clang++ 17.0.0 -fPIC -O3)

X0 N2 1 INV_X1
X1 N7 2 INV_X1
X2 N1 N3 3 NAND2_X1
X3 N3 N6 4 AND2_X1
X4 3 4 1 N22 OAI21_X1
X5 4 2 1 N23 AOI21_X1

************************
* end of SPICE netlist *
************************
