* NANGATE 45nm MOCK SUBCIRCUITS FOR LOGIC GATES (2-port to 4-port mappings)
* Note: Global VDD/VSS are hardcoded to node 1 and 0 (GND) for simulation purposes

.SUBCKT INV_X1 A Z
M1 Z A 0 0 NMOS W=0.2u L=0.05u
M2 Z A 1 1 PMOS W=0.4u L=0.05u
.ENDS

.SUBCKT NAND2_X1 A1 A2 Z
M1 Z A1 1 1 PMOS W=0.4u L=0.05u
M2 Z A2 1 1 PMOS W=0.4u L=0.05u
M3 Z A1 int 0 NMOS W=0.2u L=0.05u
M4 int A2 0 0 NMOS W=0.2u L=0.05u
.ENDS

.SUBCKT AND2_X1 A1 A2 Z
X1 A1 A2 Z_bar NAND2_X1
X2 Z_bar Z INV_X1
.ENDS

.SUBCKT OAI21_X1 A B C Z
M1 Z A 1 1 PMOS W=0.4u L=0.05u
M2 Z B int1 1 PMOS W=0.4u L=0.05u
M3 int1 C 1 1 PMOS W=0.4u L=0.05u
M4 Z A 0 0 NMOS W=0.2u L=0.05u
M5 Z B 0 0 NMOS W=0.2u L=0.05u
M6 Z C 0 0 NMOS W=0.2u L=0.05u
.ENDS

.SUBCKT AOI21_X1 A B C Z
M1 Z A int1 1 PMOS W=0.4u L=0.05u
M2 int1 B 1 1 PMOS W=0.4u L=0.05u
M3 Z C 1 1 PMOS W=0.4u L=0.05u
M4 Z A 0 0 NMOS W=0.2u L=0.05u
M5 Z B 0 0 NMOS W=0.2u L=0.05u
M6 Z C 0 0 NMOS W=0.2u L=0.05u
.ENDS

* Provide VDD power source explicitly
Vvdd 1 0 1.8

* Input Signals (N1, N2, N3, N6, N7)
V_N1 N1 0 1.8
V_N2 N2 0 0.0
V_N3 N3 0 1.8
V_N6 N6 0 0.0
V_N7 N7 0 1.8

* No anti-floating shunts are needed here; the logic network is fully driven.

* Yosys Generated Netlist Below:
* SPICE netlist generated by Yosys 0.62 (git sha1 7326bb7d6641500ecb285c291a54a662cb1e76cf, clang++ 17.0.0 -fPIC -O3)

X0 N2 1 INV_X1
X1 N7 2 INV_X1
X2 N1 N3 3 NAND2_X1
X3 N3 N6 4 AND2_X1
X4 3 4 1 N22 OAI21_X1
X5 4 2 1 N23 AOI21_X1

************************
* end of SPICE netlist *
************************
