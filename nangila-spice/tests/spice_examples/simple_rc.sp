* Simple RC Test Circuit for Nangila
.PARAM vdd_val=1.8

V1 VDD 0 DC vdd_val
R1 VDD N1 1k
C1 N1 0 10f

.END
